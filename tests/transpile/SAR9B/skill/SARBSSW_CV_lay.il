gdssLibName = "SAR9B"
 pdkLib = "SAR9B"
;- Create cell SARBSSW_CV
(let (layout net fig )
 layout = dbOpenCellViewByType(gdssLibName "SARBSSW_CV" "layout" "maskLayout" "w")
mstr = dbOpenCellViewByType( pdkLib "NCHDLR" "layout")
layInst=dbCreateInst(layout mstr "M1" 0.0:0.0 "R0")
mstr = dbOpenCellViewByType( pdkLib "NCHDLR" "layout")
layInst=dbCreateInst(layout mstr "M2" 0.0:0.344 "R0")
mstr = dbOpenCellViewByType( pdkLib "NCHDLR" "layout")
layInst=dbCreateInst(layout mstr "M3" 0.0:0.688 "R0")
mstr = dbOpenCellViewByType( pdkLib "NCHDLR" "layout")
layInst=dbCreateInst(layout mstr "M4" 0.0:1.032 "R0")
mstr = dbOpenCellViewByType( pdkLib "NCHDLR" "layout")
layInst=dbCreateInst(layout mstr "M5" 0.0:1.376 "R0")
mstr = dbOpenCellViewByType( pdkLib "NCHDLR" "layout")
layInst=dbCreateInst(layout mstr "M6" 0.0:1.72 "R0")
mstr = dbOpenCellViewByType( pdkLib "NCHDLR" "layout")
layInst=dbCreateInst(layout mstr "M7" 0.0:2.064 "R0")
mstr = dbOpenCellViewByType( pdkLib "NCHDLR" "layout")
layInst=dbCreateInst(layout mstr "M8" 0.0:2.408 "R0")
mstr = dbOpenCellViewByType( pdkLib "IVX1_CV" "layout")
layInst=dbCreateInst(layout mstr "XA0" 1.72:0.0 "R0")
mstr = dbOpenCellViewByType( pdkLib "TGPD_CV" "layout")
layInst=dbCreateInst(layout mstr "XA3" 1.72:0.344 "R0")
mstr = dbOpenCellViewByType( pdkLib "SARBSSWCTRL_CV" "layout")
layInst=dbCreateInst(layout mstr "XA4" 1.72:1.376 "R0")
mstr = dbOpenCellViewByType( pdkLib "TIEH_CV" "layout")
layInst=dbCreateInst(layout mstr "XA1" 1.72:2.064 "R0")
mstr = dbOpenCellViewByType( pdkLib "TIEL_CV" "layout")
layInst=dbCreateInst(layout mstr "XA2" 1.72:2.408 "R0")
mstr = dbOpenCellViewByType( pdkLib "TAPCELL_CV" "layout")
layInst=dbCreateInst(layout mstr "XA5" 1.72:2.752 "R0")
mstr = dbOpenCellViewByType( pdkLib "CAPX1_CV" "layout")
layInst=dbCreateInst(layout mstr "XCAPB0" 5.16:0.0 "R0")
mstr = dbOpenCellViewByType( pdkLib "CAPX1_CV" "layout")
layInst=dbCreateInst(layout mstr "XCAPB1" 5.16:0.344 "R0")
mstr = dbOpenCellViewByType( pdkLib "CAPX1_CV" "layout")
layInst=dbCreateInst(layout mstr "XCAPB2" 5.16:0.688 "R0")
mstr = dbOpenCellViewByType( pdkLib "CAPX1_CV" "layout")
layInst=dbCreateInst(layout mstr "XCAPB3" 5.16:1.032 "R0")
mstr = dbOpenCellViewByType( pdkLib "CAPX1_CV" "layout")
layInst=dbCreateInst(layout mstr "XCAPB4" 5.16:1.376 "R0")
mstr = dbOpenCellViewByType( pdkLib "CAPX1_CV" "layout")
layInst=dbCreateInst(layout mstr "XCAPB5" 5.16:1.72 "R0")
mstr = dbOpenCellViewByType( pdkLib "CAPX1_CV" "layout")
layInst=dbCreateInst(layout mstr "XCAPB6" 5.16:2.064 "R0")
mstr = dbOpenCellViewByType( pdkLib "CAPX1_CV" "layout")
layInst=dbCreateInst(layout mstr "XCAPC0" 8.6:0.0 "R0")
mstr = dbOpenCellViewByType( pdkLib "CAPX1_CV" "layout")
layInst=dbCreateInst(layout mstr "XCAPC1" 8.6:0.344 "R0")
mstr = dbOpenCellViewByType( pdkLib "CAPX1_CV" "layout")
layInst=dbCreateInst(layout mstr "XCAPC2" 8.6:0.688 "R0")
mstr = dbOpenCellViewByType( pdkLib "CAPX1_CV" "layout")
layInst=dbCreateInst(layout mstr "XCAPC3" 8.6:1.032 "R0")
mstr = dbOpenCellViewByType( pdkLib "CAPX1_CV" "layout")
layInst=dbCreateInst(layout mstr "XCAPC4" 8.6:1.376 "R0")
mstr = dbOpenCellViewByType( pdkLib "CAPX1_CV" "layout")
layInst=dbCreateInst(layout mstr "XCAPC5" 8.6:1.72 "R0")
mstr = dbOpenCellViewByType( pdkLib "CAPX1_CV" "layout")
layInst=dbCreateInst(layout mstr "XCAPC6" 8.6:2.064 "R0")
mstr = dbOpenCellViewByType( pdkLib "cut_M1M3_2x1" "layout")
layInst=dbCreateInst(layout mstr "" 3.784:1.604 "R0")
mstr = dbOpenCellViewByType( pdkLib "cut_M3M4_2x1" "layout")
layInst=dbCreateInst(layout mstr "" 4.3:1.604 "R0")
fig = dbCreateRect(layout list(42 -1) list(3.784:1.604 4.3:1.664))
fig = dbCreateRect(layout list(34 -1) list(0.902:0.228 1.204:0.288))
fig = dbCreateRect(layout list(34 -1) list(0.902:0.572 1.204:0.632))
fig = dbCreateRect(layout list(34 -1) list(0.902:0.916 1.204:0.976))
fig = dbCreateRect(layout list(34 -1) list(0.902:1.26 1.204:1.32))
fig = dbCreateRect(layout list(34 -1) list(0.902:1.604 1.204:1.664))
fig = dbCreateRect(layout list(34 -1) list(0.902:1.948 1.204:2.008))
fig = dbCreateRect(layout list(34 -1) list(0.902:2.292 1.204:2.352))
fig = dbCreateRect(layout list(34 -1) list(0.902:2.636 1.204:2.696))
fig = dbCreateRect(layout list(34 -1) list(0.902:0.228 0.962:2.696))
dbCreateLabel(layout list(58 -1) 1.032:0.228 "VI" "centerLeft" "R0" "stick" 0.1)
fig = dbCreateRect(layout list(34 -1) list(0.572:0.142 0.632:1.234))
dbCreateLabel(layout list(58 -1) 0.43:0.142 "GN" "centerLeft" "R0" "stick" 0.1)
mstr = dbOpenCellViewByType( pdkLib "cut_M1M2_2x1" "layout")
layInst=dbCreateInst(layout mstr "" 3.784:0.228 "R0")
mstr = dbOpenCellViewByType( pdkLib "cut_M1M2_2x1" "layout")
layInst=dbCreateInst(layout mstr "" 4.386:0.486 "R0")
mstr = dbOpenCellViewByType( pdkLib "cut_M1M2_2x1" "layout")
layInst=dbCreateInst(layout mstr "" 4.386:1.518 "R0")
fig = dbCreateRect(layout list(36 -1) list(3.956:0.228 4.198:0.288))
fig = dbCreateRect(layout list(36 -1) list(4.198:0.486 4.558:0.546))
fig = dbCreateRect(layout list(36 -1) list(4.198:1.518 4.558:1.578))
fig = dbCreateRect(layout list(36 -1) list(4.198:0.228 4.258:1.578))
dbCreateLabel(layout list(58 -1) 3.784:0.228 "CKN" "centerLeft" "R0" "stick" 0.1)
fig = dbCreateRect(layout list(34 -1) list(0.572:1.518 0.632:2.61))
dbCreateLabel(layout list(58 -1) 0.43:1.518 "TIE_L" "centerLeft" "R0" "stick" 0.1)
mstr = dbOpenCellViewByType( pdkLib "cut_M1M2_2x1" "layout")
layInst=dbCreateInst(layout mstr "" 2.15:1.862 "R0")
mstr = dbOpenCellViewByType( pdkLib "cut_M1M2_2x1" "layout")
layInst=dbCreateInst(layout mstr "" 3.784:2.292 "R0")
fig = dbCreateRect(layout list(36 -1) list(2.322:1.862 2.564:1.922))
fig = dbCreateRect(layout list(36 -1) list(2.564:2.292 3.956:2.352))
fig = dbCreateRect(layout list(36 -1) list(2.564:1.862 2.624:2.352))
dbCreateLabel(layout list(58 -1) 2.15:1.862 "TIE_H" "centerLeft" "R0" "stick" 0.1)
mstr = dbOpenCellViewByType( pdkLib "cut_M1M2_2x1" "layout")
layInst=dbCreateInst(layout mstr "" 0.43:2.55 "R0")
mstr = dbOpenCellViewByType( pdkLib "cut_M1M2_2x1" "layout")
layInst=dbCreateInst(layout mstr "" 2.752:2.636 "R0")
fig = dbCreateRect(layout list(36 -1) list(0.602:2.55 0.844:2.61))
fig = dbCreateRect(layout list(36 -1) list(0.844:2.636 2.924:2.696))
fig = dbCreateRect(layout list(36 -1) list(0.844:2.55 0.904:2.696))
dbCreateLabel(layout list(58 -1) 0.43:2.55 "TIE_L" "centerLeft" "R0" "stick" 0.1)
mstr = dbOpenCellViewByType( pdkLib "cut_M1M2_2x1" "layout")
layInst=dbCreateInst(layout mstr "" 1.032:0.916 "R0")
mstr = dbOpenCellViewByType( pdkLib "cut_M1M2_2x1" "layout")
layInst=dbCreateInst(layout mstr "" 2.752:1.26 "R0")
fig = dbCreateRect(layout list(36 -1) list(1.204:0.916 1.446:0.976))
fig = dbCreateRect(layout list(36 -1) list(1.446:1.26 2.924:1.32))
fig = dbCreateRect(layout list(36 -1) list(1.446:0.916 1.506:1.32))
dbCreateLabel(layout list(58 -1) 1.032:0.916 "VI" "centerLeft" "R0" "stick" 0.1)
mstr = dbOpenCellViewByType( pdkLib "cut_M1M3_2x1" "layout")
layInst=dbCreateInst(layout mstr "" 0.43:1.174 "R0")
mstr = dbOpenCellViewByType( pdkLib "cut_M1M3_2x1" "layout")
layInst=dbCreateInst(layout mstr "" 2.752:1.948 "R0")
fig = dbCreateRect(layout list(42 -1) list(0.602:1.174 0.844:1.234))
fig = dbCreateRect(layout list(42 -1) list(0.844:1.948 2.924:2.008))
fig = dbCreateRect(layout list(42 -1) list(0.844:1.174 0.904:2.008))
dbCreateLabel(layout list(58 -1) 0.43:1.174 "GN" "centerLeft" "R0" "stick" 0.1)
fig = dbCreateRect(layout list(46 -1) list(4.987:0.486 6.02:0.546))
fig = dbCreateRect(layout list(46 -1) list(4.465:1.604 4.987:1.664))
fig = dbCreateRect(layout list(46 -1) list(4.987:0.486 5.047:1.664))
dbCreateLabel(layout list(58 -1) 5.117:0.486 "GNG" "centerLeft" "R0" "stick" 0.1)
mstr = dbOpenCellViewByType( pdkLib "cut_M1M3_2x1" "layout")
layInst=dbCreateInst(layout mstr "" 3.784:1.088 "R0")
fig = dbCreateRect(layout list(42 -1) list(3.956:1.088 4.198:1.148))
fig = dbCreateRect(layout list(42 -1) list(4.198:0.215 6.88:0.275))
fig = dbCreateRect(layout list(42 -1) list(4.198:0.215 4.258:1.148))
dbCreateLabel(layout list(58 -1) 3.784:1.088 "VS" "centerLeft" "R0" "stick" 0.1)
fig = dbCreateRect(layout list(46 -1) list(9.46:0.142 12.223:0.202))
fig = dbCreateRect(layout list(46 -1) list(9.46:0.486 12.223:0.546))
fig = dbCreateRect(layout list(46 -1) list(9.46:0.83 12.223:0.89))
fig = dbCreateRect(layout list(46 -1) list(9.46:1.174 12.223:1.234))
fig = dbCreateRect(layout list(46 -1) list(9.46:1.518 12.223:1.578))
fig = dbCreateRect(layout list(46 -1) list(9.46:1.862 12.223:1.922))
fig = dbCreateRect(layout list(46 -1) list(9.46:2.206 12.223:2.266))
fig = dbCreateRect(layout list(46 -1) list(12.223:0.142 12.283:2.266))
dbCreateLabel(layout list(58 -1) 8.557:0.142 "GNG" "centerLeft" "R0" "stick" 0.1)
fig = dbCreateRect(layout list(42 -1) list(12.04:0.215 12.153:0.275))
fig = dbCreateRect(layout list(42 -1) list(12.04:0.559 12.153:0.619))
fig = dbCreateRect(layout list(42 -1) list(12.04:0.903 12.153:0.963))
fig = dbCreateRect(layout list(42 -1) list(12.04:1.247 12.153:1.307))
fig = dbCreateRect(layout list(42 -1) list(12.04:1.591 12.153:1.651))
fig = dbCreateRect(layout list(42 -1) list(12.04:1.935 12.153:1.995))
fig = dbCreateRect(layout list(42 -1) list(12.04:2.279 12.153:2.339))
fig = dbCreateRect(layout list(42 -1) list(12.153:0.215 12.213:2.339))
dbCreateLabel(layout list(58 -1) 11.997:0.215 "VS" "centerLeft" "R0" "stick" 0.1)
fig = dbCreateRect(layout list(34 -1) list(1.204:0.056 1.446:0.116))
fig = dbCreateRect(layout list(34 -1) list(1.204:0.4 1.446:0.46))
fig = dbCreateRect(layout list(34 -1) list(1.204:0.744 1.446:0.804))
fig = dbCreateRect(layout list(34 -1) list(1.204:1.088 1.446:1.148))
fig = dbCreateRect(layout list(34 -1) list(1.446:0.056 1.506:1.148))
dbCreateLabel(layout list(58 -1) 1.032:0.056 "VO1" "centerLeft" "R0" "stick" 0.1)
fig = dbCreateRect(layout list(34 -1) list(1.204:1.432 1.446:1.492))
fig = dbCreateRect(layout list(34 -1) list(1.204:1.776 1.446:1.836))
fig = dbCreateRect(layout list(34 -1) list(1.204:2.12 1.446:2.18))
fig = dbCreateRect(layout list(34 -1) list(1.204:2.464 1.446:2.524))
fig = dbCreateRect(layout list(34 -1) list(1.446:1.432 1.506:2.524))
dbCreateLabel(layout list(58 -1) 1.032:1.432 "VO2" "centerLeft" "R0" "stick" 0.1)
fig = dbCreateRect(layout list(46 -1) list(1.046:0.233 1.376:0.283))
net = dbCreateNet(layout "VI")
dbCreateTerm( net "VI" "inputOutput")
dbCreatePin(net fig)
dbCreateLabel(layout list(46 237) 1.046:0.233 "VI" "centerLeft" "R0" "stick" 0.1)
mstr = dbOpenCellViewByType( pdkLib "cut_M1M4_2x1" "layout")
layInst=dbCreateInst(layout mstr "" 1.046:0.233 "R0")
fig = dbCreateRect(layout list(46 -1) list(1.776:2.641 2.106:2.691))
net = dbCreateNet(layout "TIE_L")
dbCreateTerm( net "TIE_L" "inputOutput")
dbCreatePin(net fig)
dbCreateLabel(layout list(46 237) 1.776:2.641 "TIE_L" "centerLeft" "R0" "stick" 0.1)
mstr = dbOpenCellViewByType( pdkLib "cut_M2M4_2x1" "layout")
layInst=dbCreateInst(layout mstr "" 1.776:2.641 "R0")
fig = dbCreateRect(layout list(34 -1) list(2.15:0.142 2.494:0.202))
net = dbCreateNet(layout "CK")
dbCreateTerm( net "CK" "inputOutput")
dbCreatePin(net fig)
dbCreateLabel(layout list(34 237) 2.15:0.142 "CK" "centerLeft" "R0" "stick" 0.1)
fig = dbCreateRect(layout list(34 -1) list(4.386:0.486 4.73:0.546))
net = dbCreateNet(layout "CKN")
dbCreateTerm( net "CKN" "inputOutput")
dbCreatePin(net fig)
dbCreateLabel(layout list(34 237) 4.386:0.486 "CKN" "centerLeft" "R0" "stick" 0.1)
fig = dbCreateRect(layout list(34 -1) list(1.032:1.088 1.376:1.148))
net = dbCreateNet(layout "VO1")
dbCreateTerm( net "VO1" "inputOutput")
dbCreatePin(net fig)
dbCreateLabel(layout list(34 237) 1.032:1.088 "VO1" "centerLeft" "R0" "stick" 0.1)
fig = dbCreateRect(layout list(34 -1) list(1.032:2.464 1.376:2.524))
net = dbCreateNet(layout "VO2")
dbCreateTerm( net "VO2" "inputOutput")
dbCreatePin(net fig)
dbCreateLabel(layout list(34 237) 1.032:2.464 "VO2" "centerLeft" "R0" "stick" 0.1)
fig = dbCreateRect(layout list(46 -1) list(3.784:0.0 4.114:3.096))
net = dbCreateNet(layout "AVDD")
dbCreateTerm( net "AVDD" "inputOutput")
dbCreatePin(net fig)
dbCreateLabel(layout list(46 237) 3.784:0.0 "AVDD" "centerLeft" "R0" "stick" 0.1)
fig = dbCreateRect(layout list(46 -1) list(2.752:0.0 3.082:3.096))
net = dbCreateNet(layout "AVSS")
dbCreateTerm( net "AVSS" "inputOutput")
dbCreatePin(net fig)
dbCreateLabel(layout list(46 237) 2.752:0.0 "AVSS" "centerLeft" "R0" "stick" 0.1)
fig = dbCreateRect(layout list(46 -1) list(3.784:0.0 4.114:3.096))
mstr = dbOpenCellViewByType( pdkLib "cut_M1M4_2x1" "layout")
layInst=dbCreateInst(layout mstr "" 2.752:2.98 "R0")
fig = dbCreateRect(layout list(46 -1) list(2.752:0.0 3.082:3.096))
 dbSave(layout) )
