objs = geGetSelectedSet()
(foreach o objs

        if(rexMatchp("MN2" o~>name) then
            dbMoveFig(o nil list(0.0:0.0 "R0"))

        )

        if(rexMatchp("MN1" o~>name) then
            dbMoveFig(o nil list(3.92:0.0 "MY"))

        )

        if(rexMatchp("MN1" o~>name) then
            dbMoveFig(o nil list(3.92:0.0 "R0"))

        )

        if(rexMatchp("MN2" o~>name) then
            dbMoveFig(o nil list(7.84:0.0 "MY"))

        )

        if(rexMatchp("MN1" o~>name) then
            dbMoveFig(o nil list(0.0:0.67 "R0"))

        )

        if(rexMatchp("MN2" o~>name) then
            dbMoveFig(o nil list(3.92:0.67 "MY"))

        )

        if(rexMatchp("MN2" o~>name) then
            dbMoveFig(o nil list(3.92:0.67 "R0"))

        )

        if(rexMatchp("MN1" o~>name) then
            dbMoveFig(o nil list(7.84:0.67 "MY"))

        )

        if(rexMatchp("MN2" o~>name) then
            dbMoveFig(o nil list(0.0:1.34 "R0"))

        )

        if(rexMatchp("MN1" o~>name) then
            dbMoveFig(o nil list(3.92:1.34 "MY"))

        )

        if(rexMatchp("MN1" o~>name) then
            dbMoveFig(o nil list(3.92:1.34 "R0"))

        )

        if(rexMatchp("MN2" o~>name) then
            dbMoveFig(o nil list(7.84:1.34 "MY"))

        )

        if(rexMatchp("MN1" o~>name) then
            dbMoveFig(o nil list(0.0:2.0100000000000002 "R0"))

        )

        if(rexMatchp("MN2" o~>name) then
            dbMoveFig(o nil list(3.92:2.0100000000000002 "MY"))

        )

        if(rexMatchp("MN2" o~>name) then
            dbMoveFig(o nil list(3.92:2.0100000000000002 "R0"))

        )

        if(rexMatchp("MN1" o~>name) then
            dbMoveFig(o nil list(7.84:2.0100000000000002 "MY"))

        )

        )
