gdssLibName = "SAR9B"
 pdkLib = "SAR9B"
;- Create cell SARCEX1_CV
(let (layout net fig )
 layout = dbOpenCellViewByType(gdssLibName "SARCEX1_CV" "layout" "maskLayout" "w")
mstr = dbOpenCellViewByType( pdkLib "NCHDL" "layout")
layInst=dbCreateInst(layout mstr "MN0" 0.0:0.0 "R0")
mstr = dbOpenCellViewByType( pdkLib "NCHDL" "layout")
layInst=dbCreateInst(layout mstr "MN1" 0.0:0.344 "R0")
mstr = dbOpenCellViewByType( pdkLib "NCHDL" "layout")
layInst=dbCreateInst(layout mstr "MN2" 0.0:0.688 "R0")
mstr = dbOpenCellViewByType( pdkLib "NCHDL" "layout")
layInst=dbCreateInst(layout mstr "MN3" 0.0:1.032 "R0")
mstr = dbOpenCellViewByType( pdkLib "PCHDL" "layout")
layInst=dbCreateInst(layout mstr "MP0" 1.72:0.0 "R0")
mstr = dbOpenCellViewByType( pdkLib "PCHDL" "layout")
layInst=dbCreateInst(layout mstr "MP1" 1.72:0.344 "R0")
mstr = dbOpenCellViewByType( pdkLib "PCHDL" "layout")
layInst=dbCreateInst(layout mstr "MP2" 1.72:0.688 "R0")
mstr = dbOpenCellViewByType( pdkLib "PCHDL" "layout")
layInst=dbCreateInst(layout mstr "MP3" 1.72:1.032 "R0")
fig = dbCreateRect(layout list(34 -1) list(1.204:1.26 1.446:1.32))
fig = dbCreateRect(layout list(34 -1) list(1.446:0.056 2.236:0.116))
fig = dbCreateRect(layout list(34 -1) list(1.446:1.26 2.236:1.32))
fig = dbCreateRect(layout list(34 -1) list(1.446:0.056 1.506:1.32))
dbCreateLabel(layout list(58 -1) 1.032:1.26 "CHL" "centerLeft" "R0" "stick" 0.1)
fig = dbCreateRect(layout list(34 -1) list(0.572:0.142 0.632:1.234))
dbCreateLabel(layout list(58 -1) 0.43:0.142 "RST" "centerLeft" "R0" "stick" 0.1)
fig = dbCreateRect(layout list(34 -1) list(2.808:0.142 2.868:0.546))
dbCreateLabel(layout list(58 -1) 2.666:0.486 "A" "centerLeft" "R0" "stick" 0.1)
fig = dbCreateRect(layout list(34 -1) list(2.808:0.83 2.868:1.234))
dbCreateLabel(layout list(58 -1) 2.666:0.83 "B" "centerLeft" "R0" "stick" 0.1)
fig = dbCreateRect(layout list(34 -1) list(2.666:0.142 3.01:0.202))
net = dbCreateNet(layout "A")
dbCreateTerm( net "A" "inputOutput")
dbCreatePin(net fig)
dbCreateLabel(layout list(34 237) 2.666:0.142 "A" "centerLeft" "R0" "stick" 0.1)
fig = dbCreateRect(layout list(34 -1) list(2.666:0.83 3.01:0.89))
net = dbCreateNet(layout "B")
dbCreateTerm( net "B" "inputOutput")
dbCreatePin(net fig)
dbCreateLabel(layout list(34 237) 2.666:0.83 "B" "centerLeft" "R0" "stick" 0.1)
fig = dbCreateRect(layout list(34 -1) list(0.43:0.486 0.774:0.546))
net = dbCreateNet(layout "RST")
dbCreateTerm( net "RST" "inputOutput")
dbCreatePin(net fig)
dbCreateLabel(layout list(34 237) 0.43:0.486 "RST" "centerLeft" "R0" "stick" 0.1)
fig = dbCreateRect(layout list(34 -1) list(1.032:1.26 1.376:1.32))
net = dbCreateNet(layout "Y")
dbCreateTerm( net "Y" "inputOutput")
dbCreatePin(net fig)
dbCreateLabel(layout list(34 237) 1.032:1.26 "Y" "centerLeft" "R0" "stick" 0.1)
fig = dbCreateRect(layout list(46 -1) list(2.064:0.0 2.394:1.376))
net = dbCreateNet(layout "AVDD")
dbCreateTerm( net "AVDD" "inputOutput")
dbCreatePin(net fig)
dbCreateLabel(layout list(46 237) 2.064:0.0 "AVDD" "centerLeft" "R0" "stick" 0.1)
fig = dbCreateRect(layout list(46 -1) list(1.032:0.0 1.362:1.376))
net = dbCreateNet(layout "AVSS")
dbCreateTerm( net "AVSS" "inputOutput")
dbCreatePin(net fig)
dbCreateLabel(layout list(46 237) 1.032:0.0 "AVSS" "centerLeft" "R0" "stick" 0.1)
mstr = dbOpenCellViewByType( pdkLib "cut_M1M4_2x1" "layout")
layInst=dbCreateInst(layout mstr "" 2.064:0.572 "R0")
mstr = dbOpenCellViewByType( pdkLib "cut_M1M4_2x1" "layout")
layInst=dbCreateInst(layout mstr "" 2.064:0.744 "R0")
fig = dbCreateRect(layout list(46 -1) list(2.064:0.0 2.394:1.376))
mstr = dbOpenCellViewByType( pdkLib "cut_M1M4_2x1" "layout")
layInst=dbCreateInst(layout mstr "" 1.032:0.056 "R0")
mstr = dbOpenCellViewByType( pdkLib "cut_M1M4_2x1" "layout")
layInst=dbCreateInst(layout mstr "" 1.032:0.572 "R0")
mstr = dbOpenCellViewByType( pdkLib "cut_M1M4_2x1" "layout")
layInst=dbCreateInst(layout mstr "" 1.032:0.744 "R0")
fig = dbCreateRect(layout list(46 -1) list(1.032:0.0 1.362:1.376))
 dbSave(layout) )
