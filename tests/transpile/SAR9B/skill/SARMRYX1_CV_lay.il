gdssLibName = "SAR9B"
 pdkLib = "SAR9B"
;- Create cell SARMRYX1_CV
(let (layout net fig )
 layout = dbOpenCellViewByType(gdssLibName "SARMRYX1_CV" "layout" "maskLayout" "w")
mstr = dbOpenCellViewByType( pdkLib "TAPCELL_CV" "layout")
layInst=dbCreateInst(layout mstr "XA0" 0.0:0.0 "R0")
mstr = dbOpenCellViewByType( pdkLib "SAREMX1_CV" "layout")
layInst=dbCreateInst(layout mstr "XA1" 0.0:0.344 "R0")
mstr = dbOpenCellViewByType( pdkLib "IVX1_CV" "layout")
layInst=dbCreateInst(layout mstr "XA2" 0.0:1.72 "R0")
mstr = dbOpenCellViewByType( pdkLib "SARLTX1_CV" "layout")
layInst=dbCreateInst(layout mstr "XA4" 0.0:2.064 "R0")
mstr = dbOpenCellViewByType( pdkLib "SARLTX1_CV" "layout")
layInst=dbCreateInst(layout mstr "XA5" 0.0:3.096 "R0")
fig = dbCreateRect(layout list(34 -1) list(2.838:0.486 3.08:0.546))
fig = dbCreateRect(layout list(34 -1) list(2.838:2.894 3.08:2.954))
fig = dbCreateRect(layout list(34 -1) list(2.838:3.926 3.08:3.986))
fig = dbCreateRect(layout list(34 -1) list(3.08:0.486 3.14:3.986))
dbCreateLabel(layout list(58 -1) 2.666:0.486 "RST_N" "centerLeft" "R0" "stick" 0.1)
fig = dbCreateRect(layout list(34 -1) list(0.714:1.802 0.844:1.862))
fig = dbCreateRect(layout list(34 -1) list(0.844:1.604 1.204:1.664))
fig = dbCreateRect(layout list(34 -1) list(0.844:1.604 0.904:1.862))
fig = dbCreateRect(layout list(34 -1) list(0.602:1.862 0.774:1.922))
dbCreateLabel(layout list(58 -1) 0.43:1.862 "ENO" "centerLeft" "R0" "stick" 0.1)
fig = dbCreateRect(layout list(34 -1) list(0.602:3.582 0.844:3.642))
fig = dbCreateRect(layout list(34 -1) list(0.844:1.948 1.204:2.008))
fig = dbCreateRect(layout list(34 -1) list(0.844:1.948 0.904:3.642))
dbCreateLabel(layout list(58 -1) 0.43:3.582 "LCK_N" "centerLeft" "R0" "stick" 0.1)
fig = dbCreateRect(layout list(34 -1) list(0.602:2.55 0.844:2.61))
fig = dbCreateRect(layout list(34 -1) list(0.844:1.948 1.204:2.008))
fig = dbCreateRect(layout list(34 -1) list(0.844:1.948 0.904:2.61))
dbCreateLabel(layout list(58 -1) 0.43:2.55 "LCK_N" "centerLeft" "R0" "stick" 0.1)
fig = dbCreateRect(layout list(34 -1) list(0.3:0.83 0.602:0.89))
fig = dbCreateRect(layout list(34 -1) list(0.3:3.238 0.602:3.298))
fig = dbCreateRect(layout list(34 -1) list(0.3:0.83 0.36:3.298))
dbCreateLabel(layout list(58 -1) 0.43:0.83 "CMP_OP" "centerLeft" "R0" "stick" 0.1)
mstr = dbOpenCellViewByType( pdkLib "cut_M1M2_2x1" "layout")
layInst=dbCreateInst(layout mstr "" 0.444:1.174 "R0")
mstr = dbOpenCellViewByType( pdkLib "cut_M1M2_2x1" "layout")
layInst=dbCreateInst(layout mstr "" 0.444:2.206 "R0")
fig = dbCreateRect(layout list(36 -1) list(0.602:1.174 0.844:1.234))
fig = dbCreateRect(layout list(36 -1) list(0.602:2.206 0.844:2.266))
fig = dbCreateRect(layout list(36 -1) list(0.844:1.174 0.904:2.266))
dbCreateLabel(layout list(58 -1) 0.43:1.174 "CMP_ON" "centerLeft" "R0" "stick" 0.1)
mstr = dbOpenCellViewByType( pdkLib "cut_M1M2_2x1" "layout")
layInst=dbCreateInst(layout mstr "" 0.43:0.486 "R0")
mstr = dbOpenCellViewByType( pdkLib "cut_M1M2_2x1" "layout")
layInst=dbCreateInst(layout mstr "" 0.43:3.926 "R0")
mstr = dbOpenCellViewByType( pdkLib "cut_M1M2_2x1" "layout")
layInst=dbCreateInst(layout mstr "" 0.43:2.894 "R0")
fig = dbCreateRect(layout list(36 -1) list(0.3:0.486 0.602:0.546))
fig = dbCreateRect(layout list(36 -1) list(0.3:3.926 0.602:3.986))
fig = dbCreateRect(layout list(36 -1) list(0.3:2.894 0.602:2.954))
fig = dbCreateRect(layout list(36 -1) list(0.3:0.486 0.36:3.986))
dbCreateLabel(layout list(58 -1) 0.43:0.486 "EN" "centerLeft" "R0" "stick" 0.1)
fig = dbCreateRect(layout list(34 -1) list(0.43:2.206 0.774:2.266))
net = dbCreateNet(layout "CMP_OP")
dbCreateTerm( net "CMP_OP" "inputOutput")
dbCreatePin(net fig)
dbCreateLabel(layout list(34 237) 0.43:2.206 "CMP_OP" "centerLeft" "R0" "stick" 0.1)
fig = dbCreateRect(layout list(34 -1) list(2.666:3.926 3.01:3.986))
net = dbCreateNet(layout "RST_N")
dbCreateTerm( net "RST_N" "inputOutput")
dbCreatePin(net fig)
dbCreateLabel(layout list(34 237) 2.666:3.926 "RST_N" "centerLeft" "R0" "stick" 0.1)
fig = dbCreateRect(layout list(34 -1) list(0.43:0.486 0.774:0.546))
net = dbCreateNet(layout "EN")
dbCreateTerm( net "EN" "inputOutput")
dbCreatePin(net fig)
dbCreateLabel(layout list(34 237) 0.43:0.486 "EN" "centerLeft" "R0" "stick" 0.1)
fig = dbCreateRect(layout list(34 -1) list(0.43:3.238 0.774:3.298))
net = dbCreateNet(layout "CMP_ON")
dbCreateTerm( net "CMP_ON" "inputOutput")
dbCreatePin(net fig)
dbCreateLabel(layout list(34 237) 0.43:3.238 "CMP_ON" "centerLeft" "R0" "stick" 0.1)
fig = dbCreateRect(layout list(34 -1) list(1.032:2.98 1.376:3.04))
net = dbCreateNet(layout "CHL_OP")
dbCreateTerm( net "CHL_OP" "inputOutput")
dbCreatePin(net fig)
dbCreateLabel(layout list(34 237) 1.032:2.98 "CHL_OP" "centerLeft" "R0" "stick" 0.1)
fig = dbCreateRect(layout list(34 -1) list(1.032:4.012 1.376:4.072))
net = dbCreateNet(layout "CHL_ON")
dbCreateTerm( net "CHL_ON" "inputOutput")
dbCreatePin(net fig)
dbCreateLabel(layout list(34 237) 1.032:4.012 "CHL_ON" "centerLeft" "R0" "stick" 0.1)
fig = dbCreateRect(layout list(34 -1) list(2.064:0.744 2.408:0.804))
net = dbCreateNet(layout "ENO")
dbCreateTerm( net "ENO" "inputOutput")
dbCreatePin(net fig)
dbCreateLabel(layout list(34 237) 2.064:0.744 "ENO" "centerLeft" "R0" "stick" 0.1)
fig = dbCreateRect(layout list(46 -1) list(2.064:0.0 2.394:4.128))
net = dbCreateNet(layout "AVDD")
dbCreateTerm( net "AVDD" "inputOutput")
dbCreatePin(net fig)
dbCreateLabel(layout list(46 237) 2.064:0.0 "AVDD" "centerLeft" "R0" "stick" 0.1)
fig = dbCreateRect(layout list(46 -1) list(1.032:0.0 1.362:4.128))
net = dbCreateNet(layout "AVSS")
dbCreateTerm( net "AVSS" "inputOutput")
dbCreatePin(net fig)
dbCreateLabel(layout list(46 237) 1.032:0.0 "AVSS" "centerLeft" "R0" "stick" 0.1)
fig = dbCreateRect(layout list(46 -1) list(2.064:0.0 2.394:4.128))
mstr = dbOpenCellViewByType( pdkLib "cut_M1M4_2x1" "layout")
layInst=dbCreateInst(layout mstr "" 1.032:0.228 "R0")
fig = dbCreateRect(layout list(46 -1) list(1.032:0.0 1.362:4.128))
 dbSave(layout) )
