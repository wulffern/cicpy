load("SAR9B/skill/cut_M4M5_2x1_lay.il")
load("SAR9B/skill/cut_M4M5_1x2_lay.il")
load("SAR9B/skill/cut_M3M4_2x2_lay.il")
load("SAR9B/skill/cut_M3M4_2x1_lay.il")
load("SAR9B/skill/cut_M3M4_1x2_lay.il")
load("SAR9B/skill/cut_M2M4_2x1_lay.il")
load("SAR9B/skill/cut_M2M4_1x2_lay.il")
load("SAR9B/skill/cut_M2M3_2x1_lay.il")
load("SAR9B/skill/cut_M2M3_1x2_lay.il")
load("SAR9B/skill/cut_M1M4_2x2_lay.il")
load("SAR9B/skill/cut_M1M4_2x1_lay.il")
load("SAR9B/skill/cut_M1M4_1x2_lay.il")
load("SAR9B/skill/cut_M1M3_2x1_lay.il")
load("SAR9B/skill/cut_M1M2_2x1_lay.il")
load("SAR9B/skill/cut_M1M2_1x2_lay.il")
load("SAR9B/skill/RM1_lay.il")
load("SAR9B/skill/RM4_lay.il")
load("SAR9B/skill/CAP_lay.il")
load("SAR9B/skill/CAPR_lay.il")
load("SAR9B/skill/DMOS_lay.il")
load("SAR9B/skill/PCHDL_lay.il")
load("SAR9B/skill/NCHDL_lay.il")
load("SAR9B/skill/NCHDLR_lay.il")
load("SAR9B/skill/DMOS_BULK_lay.il")
load("SAR9B/skill/PCHDLDMY_lay.il")
load("SAR9B/skill/NCHDLDMY_lay.il")
load("SAR9B/skill/NCHDLRDMY_lay.il")
load("SAR9B/skill/TIEH_CV_lay.il")
load("SAR9B/skill/TIEL_CV_lay.il")
load("SAR9B/skill/CAPX1_CV_lay.il")
load("SAR9B/skill/IVX1_CV_lay.il")
load("SAR9B/skill/IVX2_CV_lay.il")
load("SAR9B/skill/SWX2_CV_lay.il")
load("SAR9B/skill/SWX4_CV_lay.il")
load("SAR9B/skill/TGPD_CV_lay.il")
load("SAR9B/skill/IVX4_CV_lay.il")
load("SAR9B/skill/TAPCELL_CV_lay.il")
load("SAR9B/skill/TAPCELLB_CV_lay.il")
load("SAR9B/skill/NRX1_CV_lay.il")
load("SAR9B/skill/NDX1_CV_lay.il")
load("SAR9B/skill/SAREMX1_CV_lay.il")
load("SAR9B/skill/SARLTX1_CV_lay.il")
load("SAR9B/skill/SARCEX1_CV_lay.il")
load("SAR9B/skill/SARCMPHX1_CV_lay.il")
load("SAR9B/skill/SARKICKHX1_CV_lay.il")
load("SAR9B/skill/SARBSSWCTRL_CV_lay.il")
load("SAR9B/skill/CAP32C_CV_lay.il")
load("SAR9B/skill/SARCMPX1_CV_lay.il")
load("SAR9B/skill/SARBSSW_CV_lay.il")
load("SAR9B/skill/SARMRYX1_CV_lay.il")
load("SAR9B/skill/SARDIGX1_CV_lay.il")
load("SAR9B/skill/SARDIGEX2_CV_lay.il")
load("SAR9B/skill/SARDIGEX4_CV_lay.il")
load("SAR9B/skill/CDAC9_CV_lay.il")
load("SAR9B/skill/ALGIC001_SAR9B_CV_NOROUTE_lay.il")
load("SAR9B/skill/ALGIC001_SAR9B_CV_lay.il")
