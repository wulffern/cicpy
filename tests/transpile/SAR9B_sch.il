(let (schLibName techLib inputPinMasters outputPinMasters inputOutputPinMasters sch schName)
        schLibName = "SAR9B"
    techLib = "tech"
    inputPinMaster=dbOpenCellView("basic" "ipin" "symbol" nil "r")
    outputPinMaster=dbOpenCellView("basic" "opin" "symbol" nil "r")
    inputOutputPinMaster=dbOpenCellView("basic" "iopin" "symbol" nil "r")

load("SAR9B/skill/RM1_sch.il")
load("SAR9B/skill/RM4_sch.il")
load("SAR9B/skill/CAP_sch.il")
load("SAR9B/skill/CAPR_sch.il")
load("SAR9B/skill/DMOS_sch.il")
load("SAR9B/skill/PCHDL_sch.il")
load("SAR9B/skill/NCHDL_sch.il")
load("SAR9B/skill/NCHDLR_sch.il")
load("SAR9B/skill/DMOS_BULK_sch.il")
load("SAR9B/skill/PCHDLDMY_sch.il")
load("SAR9B/skill/NCHDLDMY_sch.il")
load("SAR9B/skill/NCHDLRDMY_sch.il")
load("SAR9B/skill/TIEH_CV_sch.il")
load("SAR9B/skill/TIEL_CV_sch.il")
load("SAR9B/skill/CAPX1_CV_sch.il")
load("SAR9B/skill/IVX1_CV_sch.il")
load("SAR9B/skill/IVX2_CV_sch.il")
load("SAR9B/skill/SWX2_CV_sch.il")
load("SAR9B/skill/SWX4_CV_sch.il")
load("SAR9B/skill/TGPD_CV_sch.il")
load("SAR9B/skill/IVX4_CV_sch.il")
load("SAR9B/skill/TAPCELL_CV_sch.il")
load("SAR9B/skill/TAPCELLB_CV_sch.il")
load("SAR9B/skill/NRX1_CV_sch.il")
load("SAR9B/skill/NDX1_CV_sch.il")
load("SAR9B/skill/SAREMX1_CV_sch.il")
load("SAR9B/skill/SARLTX1_CV_sch.il")
load("SAR9B/skill/SARCEX1_CV_sch.il")
load("SAR9B/skill/SARCMPHX1_CV_sch.il")
load("SAR9B/skill/SARKICKHX1_CV_sch.il")
load("SAR9B/skill/SARBSSWCTRL_CV_sch.il")
load("SAR9B/skill/CAP32C_CV_sch.il")
load("SAR9B/skill/SARCMPX1_CV_sch.il")
load("SAR9B/skill/SARBSSW_CV_sch.il")
load("SAR9B/skill/SARMRYX1_CV_sch.il")
load("SAR9B/skill/SARDIGX1_CV_sch.il")
load("SAR9B/skill/SARDIGEX2_CV_sch.il")
load("SAR9B/skill/SARDIGEX4_CV_sch.il")
load("SAR9B/skill/CDAC9_CV_sch.il")
load("SAR9B/skill/ALGIC001_SAR9B_CV_NOROUTE_sch.il")
load("SAR9B/skill/ALGIC001_SAR9B_CV_sch.il")
)
