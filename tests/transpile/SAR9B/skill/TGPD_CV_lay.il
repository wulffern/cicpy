gdssLibName = "SAR9B"
 pdkLib = "SAR9B"
;- Create cell TGPD_CV
(let (layout net fig )
 layout = dbOpenCellViewByType(gdssLibName "TGPD_CV" "layout" "maskLayout" "w")
mstr = dbOpenCellViewByType( pdkLib "NCHDL" "layout")
layInst=dbCreateInst(layout mstr "MN0" 0.0:0.0 "R0")
mstr = dbOpenCellViewByType( pdkLib "NCHDL" "layout")
layInst=dbCreateInst(layout mstr "MN1" 0.0:0.344 "R0")
mstr = dbOpenCellViewByType( pdkLib "NCHDL" "layout")
layInst=dbCreateInst(layout mstr "MN2" 0.0:0.688 "R0")
mstr = dbOpenCellViewByType( pdkLib "PCHDL" "layout")
layInst=dbCreateInst(layout mstr "MP0" 1.72:0.0 "R0")
mstr = dbOpenCellViewByType( pdkLib "PCHDL" "layout")
layInst=dbCreateInst(layout mstr "MP1_DMY" 1.72:0.344 "R0")
mstr = dbOpenCellViewByType( pdkLib "PCHDL" "layout")
layInst=dbCreateInst(layout mstr "MP2" 1.72:0.688 "R0")
fig = dbCreateRect(layout list(34 -1) list(1.204:0.056 1.446:0.116))
fig = dbCreateRect(layout list(34 -1) list(1.446:0.056 2.236:0.116))
fig = dbCreateRect(layout list(34 -1) list(1.446:0.056 1.506:0.116))
dbCreateLabel(layout list(58 -1) 1.032:0.056 "C" "centerLeft" "R0" "stick" 0.1)
fig = dbCreateRect(layout list(30 -1) list(0.774:0.157 2.666:0.187))
dbCreateLabel(layout list(58 -1) 0.774:0.157 "C" "centerLeft" "R0" "stick" 0.1)
fig = dbCreateRect(layout list(34 -1) list(1.204:0.916 1.446:0.976))
fig = dbCreateRect(layout list(34 -1) list(1.446:0.916 2.236:0.976))
fig = dbCreateRect(layout list(34 -1) list(1.446:0.916 1.506:0.976))
dbCreateLabel(layout list(58 -1) 1.032:0.916 "A" "centerLeft" "R0" "stick" 0.1)
fig = dbCreateRect(layout list(34 -1) list(1.204:0.744 1.446:0.804))
fig = dbCreateRect(layout list(34 -1) list(1.446:0.744 2.236:0.804))
fig = dbCreateRect(layout list(34 -1) list(1.446:0.744 1.506:0.804))
dbCreateLabel(layout list(58 -1) 1.032:0.744 "B" "centerLeft" "R0" "stick" 0.1)
fig = dbCreateRect(layout list(34 -1) list(0.572:0.142 0.632:0.546))
dbCreateLabel(layout list(58 -1) 0.43:0.142 "C" "centerLeft" "R0" "stick" 0.1)
fig = dbCreateRect(layout list(34 -1) list(0.602:0.83 0.844:0.89))
fig = dbCreateRect(layout list(34 -1) list(0.844:0.056 1.204:0.116))
fig = dbCreateRect(layout list(34 -1) list(0.844:0.056 0.904:0.89))
dbCreateLabel(layout list(58 -1) 0.43:0.83 "CN" "centerLeft" "R0" "stick" 0.1)
fig = dbCreateRect(layout list(34 -1) list(2.838:0.142 3.08:0.202))
fig = dbCreateRect(layout list(34 -1) list(2.838:0.83 3.08:0.89))
fig = dbCreateRect(layout list(34 -1) list(3.08:0.142 3.14:0.89))
dbCreateLabel(layout list(58 -1) 2.666:0.142 "C" "centerLeft" "R0" "stick" 0.1)
mstr = dbOpenCellViewByType( pdkLib "cut_M1M4_2x1" "layout")
layInst=dbCreateInst(layout mstr "" 2.064:0.4 "R0")
mstr = dbOpenCellViewByType( pdkLib "cut_M1M4_2x1" "layout")
layInst=dbCreateInst(layout mstr "" 2.666:0.486 "R0")
fig = dbCreateRect(layout list(46 -1) list(2.236:0.4 2.478:0.46))
fig = dbCreateRect(layout list(46 -1) list(2.478:0.486 2.838:0.546))
fig = dbCreateRect(layout list(46 -1) list(2.478:0.4 2.538:0.546))
dbCreateLabel(layout list(58 -1) 2.064:0.4 "NC" "centerLeft" "R0" "stick" 0.1)
fig = dbCreateRect(layout list(34 -1) list(2.666:0.142 3.01:0.202))
net = dbCreateNet(layout "C")
dbCreateTerm( net "C" "inputOutput")
dbCreatePin(net fig)
dbCreateLabel(layout list(34 237) 2.666:0.142 "C" "centerLeft" "R0" "stick" 0.1)
fig = dbCreateRect(layout list(34 -1) list(2.064:0.744 2.408:0.804))
net = dbCreateNet(layout "B")
dbCreateTerm( net "B" "inputOutput")
dbCreatePin(net fig)
dbCreateLabel(layout list(34 237) 2.064:0.744 "B" "centerLeft" "R0" "stick" 0.1)
fig = dbCreateRect(layout list(34 -1) list(1.032:0.916 1.376:0.976))
net = dbCreateNet(layout "A")
dbCreateTerm( net "A" "inputOutput")
dbCreatePin(net fig)
dbCreateLabel(layout list(34 237) 1.032:0.916 "A" "centerLeft" "R0" "stick" 0.1)
fig = dbCreateRect(layout list(46 -1) list(2.064:0.0 2.394:1.032))
net = dbCreateNet(layout "AVDD")
dbCreateTerm( net "AVDD" "inputOutput")
dbCreatePin(net fig)
dbCreateLabel(layout list(46 237) 2.064:0.0 "AVDD" "centerLeft" "R0" "stick" 0.1)
fig = dbCreateRect(layout list(46 -1) list(1.032:0.0 1.362:1.032))
net = dbCreateNet(layout "AVSS")
dbCreateTerm( net "AVSS" "inputOutput")
dbCreatePin(net fig)
dbCreateLabel(layout list(46 237) 1.032:0.0 "AVSS" "centerLeft" "R0" "stick" 0.1)
mstr = dbOpenCellViewByType( pdkLib "cut_M1M4_2x1" "layout")
layInst=dbCreateInst(layout mstr "" 2.064:0.228 "R0")
fig = dbCreateRect(layout list(46 -1) list(2.064:0.0 2.394:1.032))
mstr = dbOpenCellViewByType( pdkLib "cut_M1M4_2x1" "layout")
layInst=dbCreateInst(layout mstr "" 1.032:0.228 "R0")
mstr = dbOpenCellViewByType( pdkLib "cut_M1M4_2x1" "layout")
layInst=dbCreateInst(layout mstr "" 1.032:0.4 "R0")
fig = dbCreateRect(layout list(46 -1) list(1.032:0.0 1.362:1.032))
 dbSave(layout) )
