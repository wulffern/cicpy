gdssLibName = "SAR9B"
 pdkLib = "SAR9B"
;- Create cell SARCMPHX1_CV
(let (layout net fig )
 layout = dbOpenCellViewByType(gdssLibName "SARCMPHX1_CV" "layout" "maskLayout" "w")
mstr = dbOpenCellViewByType( pdkLib "NCHDL" "layout")
layInst=dbCreateInst(layout mstr "MN0" 0.0:0.0 "R0")
mstr = dbOpenCellViewByType( pdkLib "NCHDL" "layout")
layInst=dbCreateInst(layout mstr "MN1" 0.0:0.344 "R0")
mstr = dbOpenCellViewByType( pdkLib "NCHDL" "layout")
layInst=dbCreateInst(layout mstr "MN2" 0.0:0.688 "R0")
mstr = dbOpenCellViewByType( pdkLib "NCHDL" "layout")
layInst=dbCreateInst(layout mstr "MN3" 0.0:1.032 "R0")
mstr = dbOpenCellViewByType( pdkLib "NCHDL" "layout")
layInst=dbCreateInst(layout mstr "MN4" 0.0:1.376 "R0")
mstr = dbOpenCellViewByType( pdkLib "NCHDL" "layout")
layInst=dbCreateInst(layout mstr "MN5" 0.0:1.72 "R0")
mstr = dbOpenCellViewByType( pdkLib "NCHDL" "layout")
layInst=dbCreateInst(layout mstr "MN6" 0.0:2.064 "R0")
mstr = dbOpenCellViewByType( pdkLib "PCHDL" "layout")
layInst=dbCreateInst(layout mstr "MP0" 1.72:0.0 "R0")
mstr = dbOpenCellViewByType( pdkLib "PCHDL" "layout")
layInst=dbCreateInst(layout mstr "MP1" 1.72:0.344 "R0")
mstr = dbOpenCellViewByType( pdkLib "PCHDL" "layout")
layInst=dbCreateInst(layout mstr "MP2" 1.72:0.688 "R0")
mstr = dbOpenCellViewByType( pdkLib "PCHDL" "layout")
layInst=dbCreateInst(layout mstr "MP3" 1.72:1.032 "R0")
mstr = dbOpenCellViewByType( pdkLib "PCHDL" "layout")
layInst=dbCreateInst(layout mstr "MP4" 1.72:1.376 "R0")
mstr = dbOpenCellViewByType( pdkLib "PCHDL" "layout")
layInst=dbCreateInst(layout mstr "MP5" 1.72:1.72 "R0")
mstr = dbOpenCellViewByType( pdkLib "PCHDL" "layout")
layInst=dbCreateInst(layout mstr "MP6" 1.72:2.064 "R0")
fig = dbCreateRect(layout list(30 -1) list(0.774:2.221 2.666:2.251))
dbCreateLabel(layout list(58 -1) 0.774:2.221 "VMR" "centerLeft" "R0" "stick" 0.1)
fig = dbCreateRect(layout list(34 -1) list(2.808:1.518 2.868:2.266))
dbCreateLabel(layout list(58 -1) 2.666:1.518 "VMR" "centerLeft" "R0" "stick" 0.1)
fig = dbCreateRect(layout list(34 -1) list(0.572:0.486 0.632:1.922))
dbCreateLabel(layout list(58 -1) 0.43:0.486 "CI" "centerLeft" "R0" "stick" 0.1)
fig = dbCreateRect(layout list(34 -1) list(1.204:0.572 1.446:0.632))
fig = dbCreateRect(layout list(34 -1) list(1.204:1.26 1.446:1.32))
fig = dbCreateRect(layout list(34 -1) list(1.204:1.948 1.446:2.008))
fig = dbCreateRect(layout list(34 -1) list(1.446:0.572 2.236:0.632))
fig = dbCreateRect(layout list(34 -1) list(1.446:0.572 1.506:2.008))
dbCreateLabel(layout list(58 -1) 1.032:0.572 "N2" "centerLeft" "R0" "stick" 0.1)
fig = dbCreateRect(layout list(34 -1) list(0.902:0.228 1.204:0.288))
fig = dbCreateRect(layout list(34 -1) list(0.902:0.916 1.204:0.976))
fig = dbCreateRect(layout list(34 -1) list(0.902:1.604 1.204:1.664))
fig = dbCreateRect(layout list(34 -1) list(0.902:0.228 0.962:1.664))
dbCreateLabel(layout list(58 -1) 1.032:0.228 "N1" "centerLeft" "R0" "stick" 0.1)
fig = dbCreateRect(layout list(34 -1) list(1.204:0.228 1.446:0.288))
fig = dbCreateRect(layout list(34 -1) list(1.446:0.056 2.236:0.116))
fig = dbCreateRect(layout list(34 -1) list(1.446:0.056 1.506:0.288))
dbCreateLabel(layout list(58 -1) 1.032:0.228 "N1" "centerLeft" "R0" "stick" 0.1)
fig = dbCreateRect(layout list(34 -1) list(1.934:1.26 2.236:1.32))
fig = dbCreateRect(layout list(34 -1) list(1.934:1.948 2.236:2.008))
fig = dbCreateRect(layout list(34 -1) list(1.204:2.292 1.934:2.352))
fig = dbCreateRect(layout list(34 -1) list(1.934:1.26 1.994:2.352))
dbCreateLabel(layout list(58 -1) 2.064:1.26 "CO" "centerLeft" "R0" "stick" 0.1)
fig = dbCreateRect(layout list(30 -1) list(0.774:0.157 2.666:0.187))
dbCreateLabel(layout list(58 -1) 0.774:0.157 "CK" "centerLeft" "R0" "stick" 0.1)
fig = dbCreateRect(layout list(34 -1) list(2.838:0.142 3.08:0.202))
fig = dbCreateRect(layout list(34 -1) list(2.838:0.486 3.08:0.546))
fig = dbCreateRect(layout list(34 -1) list(2.838:1.174 3.08:1.234))
fig = dbCreateRect(layout list(34 -1) list(3.08:0.142 3.14:1.234))
dbCreateLabel(layout list(58 -1) 2.666:0.142 "CK" "centerLeft" "R0" "stick" 0.1)
mstr = dbOpenCellViewByType( pdkLib "cut_M1M4_2x1" "layout")
layInst=dbCreateInst(layout mstr "" 2.064:0.916 "R0")
mstr = dbOpenCellViewByType( pdkLib "cut_M1M4_2x1" "layout")
layInst=dbCreateInst(layout mstr "" 2.666:0.83 "R0")
fig = dbCreateRect(layout list(46 -1) list(2.236:0.916 2.478:0.976))
fig = dbCreateRect(layout list(46 -1) list(2.478:0.83 2.838:0.89))
fig = dbCreateRect(layout list(46 -1) list(2.478:0.83 2.538:0.976))
dbCreateLabel(layout list(58 -1) 2.064:0.916 "NC" "centerLeft" "R0" "stick" 0.1)
fig = dbCreateRect(layout list(34 -1) list(1.032:1.604 1.376:1.664))
net = dbCreateNet(layout "N1")
dbCreateTerm( net "N1" "inputOutput")
dbCreatePin(net fig)
dbCreateLabel(layout list(34 237) 1.032:1.604 "N1" "centerLeft" "R0" "stick" 0.1)
fig = dbCreateRect(layout list(34 -1) list(1.032:1.948 1.376:2.008))
net = dbCreateNet(layout "N2")
dbCreateTerm( net "N2" "inputOutput")
dbCreatePin(net fig)
dbCreateLabel(layout list(34 237) 1.032:1.948 "N2" "centerLeft" "R0" "stick" 0.1)
fig = dbCreateRect(layout list(34 -1) list(0.43:0.486 0.774:0.546))
net = dbCreateNet(layout "CI")
dbCreateTerm( net "CI" "inputOutput")
dbCreatePin(net fig)
dbCreateLabel(layout list(34 237) 0.43:0.486 "CI" "centerLeft" "R0" "stick" 0.1)
fig = dbCreateRect(layout list(34 -1) list(0.43:0.142 0.774:0.202))
net = dbCreateNet(layout "CK")
dbCreateTerm( net "CK" "inputOutput")
dbCreatePin(net fig)
dbCreateLabel(layout list(34 237) 0.43:0.142 "CK" "centerLeft" "R0" "stick" 0.1)
fig = dbCreateRect(layout list(34 -1) list(1.032:2.292 1.376:2.352))
net = dbCreateNet(layout "CO")
dbCreateTerm( net "CO" "inputOutput")
dbCreatePin(net fig)
dbCreateLabel(layout list(34 237) 1.032:2.292 "CO" "centerLeft" "R0" "stick" 0.1)
fig = dbCreateRect(layout list(34 -1) list(0.43:2.206 0.774:2.266))
net = dbCreateNet(layout "VMR")
dbCreateTerm( net "VMR" "inputOutput")
dbCreatePin(net fig)
dbCreateLabel(layout list(34 237) 0.43:2.206 "VMR" "centerLeft" "R0" "stick" 0.1)
fig = dbCreateRect(layout list(46 -1) list(2.064:0.0 2.394:2.408))
net = dbCreateNet(layout "AVDD")
dbCreateTerm( net "AVDD" "inputOutput")
dbCreatePin(net fig)
dbCreateLabel(layout list(46 237) 2.064:0.0 "AVDD" "centerLeft" "R0" "stick" 0.1)
fig = dbCreateRect(layout list(46 -1) list(1.032:0.0 1.362:2.408))
net = dbCreateNet(layout "AVSS")
dbCreateTerm( net "AVSS" "inputOutput")
dbCreatePin(net fig)
dbCreateLabel(layout list(46 237) 1.032:0.0 "AVSS" "centerLeft" "R0" "stick" 0.1)
mstr = dbOpenCellViewByType( pdkLib "cut_M1M4_2x1" "layout")
layInst=dbCreateInst(layout mstr "" 2.064:0.228 "R0")
mstr = dbOpenCellViewByType( pdkLib "cut_M1M4_2x1" "layout")
layInst=dbCreateInst(layout mstr "" 2.064:0.4 "R0")
mstr = dbOpenCellViewByType( pdkLib "cut_M1M4_2x1" "layout")
layInst=dbCreateInst(layout mstr "" 2.064:0.916 "R0")
mstr = dbOpenCellViewByType( pdkLib "cut_M1M4_2x1" "layout")
layInst=dbCreateInst(layout mstr "" 2.064:1.088 "R0")
mstr = dbOpenCellViewByType( pdkLib "cut_M1M4_2x1" "layout")
layInst=dbCreateInst(layout mstr "" 2.064:1.604 "R0")
mstr = dbOpenCellViewByType( pdkLib "cut_M1M4_2x1" "layout")
layInst=dbCreateInst(layout mstr "" 2.064:1.776 "R0")
mstr = dbOpenCellViewByType( pdkLib "cut_M1M4_2x1" "layout")
layInst=dbCreateInst(layout mstr "" 2.064:2.292 "R0")
fig = dbCreateRect(layout list(46 -1) list(2.064:0.0 2.394:2.408))
mstr = dbOpenCellViewByType( pdkLib "cut_M1M4_2x1" "layout")
layInst=dbCreateInst(layout mstr "" 1.032:0.056 "R0")
fig = dbCreateRect(layout list(46 -1) list(1.032:0.0 1.362:2.408))
 dbSave(layout) )
