* autogenerated spice file from cicpy orc demo
.subckt ORC_TOP D G S B
x0 D G S B NCHDL
.ends ORC_TOP
