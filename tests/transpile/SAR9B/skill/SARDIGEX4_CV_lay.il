gdssLibName = "SAR9B"
 pdkLib = "SAR9B"
;- Create cell SARDIGEX4_CV
(let (layout net fig )
 layout = dbOpenCellViewByType(gdssLibName "SARDIGEX4_CV" "layout" "maskLayout" "w")
mstr = dbOpenCellViewByType( pdkLib "SARMRYX1_CV" "layout")
layInst=dbCreateInst(layout mstr "XA1" 0.0:0.0 "R0")
mstr = dbOpenCellViewByType( pdkLib "SWX4_CV" "layout")
layInst=dbCreateInst(layout mstr "XA2" 0.0:4.128 "R0")
mstr = dbOpenCellViewByType( pdkLib "SWX4_CV" "layout")
layInst=dbCreateInst(layout mstr "XA3" 0.0:5.504 "R0")
mstr = dbOpenCellViewByType( pdkLib "SWX4_CV" "layout")
layInst=dbCreateInst(layout mstr "XA4" 0.0:6.88 "R0")
mstr = dbOpenCellViewByType( pdkLib "SWX4_CV" "layout")
layInst=dbCreateInst(layout mstr "XA5" 0.0:8.256 "R0")
mstr = dbOpenCellViewByType( pdkLib "SARCEX1_CV" "layout")
layInst=dbCreateInst(layout mstr "XA6" 0.0:9.632 "R0")
mstr = dbOpenCellViewByType( pdkLib "IVX1_CV" "layout")
layInst=dbCreateInst(layout mstr "XA7" 0.0:11.008 "R0")
mstr = dbOpenCellViewByType( pdkLib "IVX1_CV" "layout")
layInst=dbCreateInst(layout mstr "XA8" 0.0:11.352 "R0")
mstr = dbOpenCellViewByType( pdkLib "NDX1_CV" "layout")
layInst=dbCreateInst(layout mstr "XA9" 0.0:11.696 "R0")
mstr = dbOpenCellViewByType( pdkLib "IVX1_CV" "layout")
layInst=dbCreateInst(layout mstr "XA10" 0.0:12.384 "R0")
mstr = dbOpenCellViewByType( pdkLib "NRX1_CV" "layout")
layInst=dbCreateInst(layout mstr "XA11" 0.0:12.728 "R0")
mstr = dbOpenCellViewByType( pdkLib "IVX1_CV" "layout")
layInst=dbCreateInst(layout mstr "XA12" 0.0:13.416 "R0")
mstr = dbOpenCellViewByType( pdkLib "TAPCELL_CV" "layout")
layInst=dbCreateInst(layout mstr "XA13" 0.0:13.76 "R0")
fig = dbCreateRect(layout list(34 -1) list(0.602:5.646 0.844:5.706))
fig = dbCreateRect(layout list(34 -1) list(0.844:4.356 1.204:4.416))
fig = dbCreateRect(layout list(34 -1) list(0.844:4.356 0.904:5.706))
dbCreateLabel(layout list(58 -1) 0.43:5.646 "CP0" "centerLeft" "R0" "stick" 0.1)
fig = dbCreateRect(layout list(34 -1) list(0.602:8.398 0.844:8.458))
fig = dbCreateRect(layout list(34 -1) list(0.844:7.108 1.204:7.168))
fig = dbCreateRect(layout list(34 -1) list(0.844:7.108 0.904:8.458))
dbCreateLabel(layout list(58 -1) 0.43:8.398 "CN1" "centerLeft" "R0" "stick" 0.1)
fig = dbCreateRect(layout list(34 -1) list(2.536:4.27 2.838:4.33))
fig = dbCreateRect(layout list(34 -1) list(2.236:4.012 2.536:4.072))
fig = dbCreateRect(layout list(34 -1) list(2.536:4.012 2.596:4.33))
dbCreateLabel(layout list(58 -1) 2.666:4.27 "CHL_OP" "centerLeft" "R0" "stick" 0.1)
mstr = dbOpenCellViewByType( pdkLib "cut_M1M2_2x1" "layout")
layInst=dbCreateInst(layout mstr "" 0.43:7.022 "R0")
mstr = dbOpenCellViewByType( pdkLib "cut_M1M2_2x1" "layout")
layInst=dbCreateInst(layout mstr "" 1.032:2.98 "R0")
fig = dbCreateRect(layout list(36 -1) list(0.602:7.022 0.844:7.082))
fig = dbCreateRect(layout list(36 -1) list(0.844:2.98 1.204:3.04))
fig = dbCreateRect(layout list(36 -1) list(0.844:2.98 0.904:7.082))
dbCreateLabel(layout list(58 -1) 0.43:7.022 "CHL_ON" "centerLeft" "R0" "stick" 0.1)
fig = dbCreateRect(layout list(46 -1) list(2.887:4.7 2.947:8.878))
dbCreateLabel(layout list(58 -1) 2.752:4.7 "VREF" "centerLeft" "R0" "stick" 0.1)
mstr = dbOpenCellViewByType( pdkLib "cut_M1M2_2x1" "layout")
layInst=dbCreateInst(layout mstr "" 2.666:11.15 "R0")
mstr = dbOpenCellViewByType( pdkLib "cut_M1M2_2x1" "layout")
layInst=dbCreateInst(layout mstr "" 2.064:0.744 "R0")
fig = dbCreateRect(layout list(36 -1) list(2.838:11.15 3.08:11.21))
fig = dbCreateRect(layout list(36 -1) list(2.236:0.744 3.08:0.804))
fig = dbCreateRect(layout list(36 -1) list(3.08:0.744 3.14:11.21))
dbCreateLabel(layout list(58 -1) 2.666:11.15 "ENO" "centerLeft" "R0" "stick" 0.1)
fig = dbCreateRect(layout list(34 -1) list(0.602:11.494 0.844:11.554))
fig = dbCreateRect(layout list(34 -1) list(0.844:11.236 1.204:11.296))
fig = dbCreateRect(layout list(34 -1) list(0.844:11.236 0.904:11.554))
dbCreateLabel(layout list(58 -1) 0.43:11.494 "ENO_N" "centerLeft" "R0" "stick" 0.1)
fig = dbCreateRect(layout list(34 -1) list(0.572:11.494 0.632:11.898))
dbCreateLabel(layout list(58 -1) 0.43:11.494 "ENO_N" "centerLeft" "R0" "stick" 0.1)
mstr = dbOpenCellViewByType( pdkLib "cut_M1M2_2x1" "layout")
layInst=dbCreateInst(layout mstr "" 0.43:12.182 "R0")
mstr = dbOpenCellViewByType( pdkLib "cut_M1M2_2x1" "layout")
layInst=dbCreateInst(layout mstr "" 1.032:10.892 "R0")
fig = dbCreateRect(layout list(36 -1) list(0.602:12.182 0.844:12.242))
fig = dbCreateRect(layout list(36 -1) list(0.844:10.892 1.204:10.952))
fig = dbCreateRect(layout list(36 -1) list(0.844:10.892 0.904:12.242))
dbCreateLabel(layout list(58 -1) 0.43:12.182 "CE" "centerLeft" "R0" "stick" 0.1)
fig = dbCreateRect(layout list(34 -1) list(0.714:12.466 0.844:12.526))
fig = dbCreateRect(layout list(34 -1) list(0.844:12.268 1.204:12.328))
fig = dbCreateRect(layout list(34 -1) list(0.844:12.268 0.904:12.526))
fig = dbCreateRect(layout list(34 -1) list(0.602:12.526 0.774:12.586))
dbCreateLabel(layout list(58 -1) 0.43:12.526 "CE1" "centerLeft" "R0" "stick" 0.1)
fig = dbCreateRect(layout list(34 -1) list(0.714:12.81 0.844:12.87))
fig = dbCreateRect(layout list(34 -1) list(0.844:12.612 1.204:12.672))
fig = dbCreateRect(layout list(34 -1) list(0.844:12.612 0.904:12.87))
fig = dbCreateRect(layout list(34 -1) list(0.602:12.87 0.774:12.93))
dbCreateLabel(layout list(58 -1) 0.43:12.87 "CE1_N" "centerLeft" "R0" "stick" 0.1)
fig = dbCreateRect(layout list(34 -1) list(0.602:13.558 0.844:13.618))
fig = dbCreateRect(layout list(34 -1) list(0.844:13.128 1.204:13.188))
fig = dbCreateRect(layout list(34 -1) list(0.844:13.128 0.904:13.618))
dbCreateLabel(layout list(58 -1) 0.43:13.558 "CEO1" "centerLeft" "R0" "stick" 0.1)
fig = dbCreateRect(layout list(34 -1) list(2.236:8.484 2.478:8.544))
fig = dbCreateRect(layout list(34 -1) list(2.478:9.774 2.838:9.834))
fig = dbCreateRect(layout list(34 -1) list(2.478:8.484 2.538:9.834))
dbCreateLabel(layout list(58 -1) 2.064:8.484 "CN0" "centerLeft" "R0" "stick" 0.1)
mstr = dbOpenCellViewByType( pdkLib "cut_M1M2_2x1" "layout")
layInst=dbCreateInst(layout mstr "" 2.064:5.732 "R0")
mstr = dbOpenCellViewByType( pdkLib "cut_M1M2_2x1" "layout")
layInst=dbCreateInst(layout mstr "" 2.666:10.462 "R0")
fig = dbCreateRect(layout list(36 -1) list(2.236:5.732 2.478:5.792))
fig = dbCreateRect(layout list(36 -1) list(2.478:10.462 2.838:10.522))
fig = dbCreateRect(layout list(36 -1) list(2.478:5.732 2.538:10.522))
dbCreateLabel(layout list(58 -1) 2.064:5.732 "CP1" "centerLeft" "R0" "stick" 0.1)
fig = dbCreateRect(layout list(42 -1) list(0.444:2.211 0.774:2.261))
net = dbCreateNet(layout "CMP_OP")
dbCreateTerm( net "CMP_OP" "inputOutput")
dbCreatePin(net fig)
dbCreateLabel(layout list(42 237) 0.444:2.211 "CMP_OP" "centerLeft" "R0" "stick" 0.1)
fig = dbCreateRect(layout list(34 -1) list(2.666:3.926 3.01:3.986))
net = dbCreateNet(layout "RST_N")
dbCreateTerm( net "RST_N" "inputOutput")
dbCreatePin(net fig)
dbCreateLabel(layout list(34 237) 2.666:3.926 "RST_N" "centerLeft" "R0" "stick" 0.1)
fig = dbCreateRect(layout list(42 -1) list(0.444:0.491 0.774:0.541))
net = dbCreateNet(layout "EN")
dbCreateTerm( net "EN" "inputOutput")
dbCreatePin(net fig)
dbCreateLabel(layout list(42 237) 0.444:0.491 "EN" "centerLeft" "R0" "stick" 0.1)
fig = dbCreateRect(layout list(34 -1) list(0.43:3.238 0.774:3.298))
net = dbCreateNet(layout "CMP_ON")
dbCreateTerm( net "CMP_ON" "inputOutput")
dbCreatePin(net fig)
dbCreateLabel(layout list(34 237) 0.43:3.238 "CMP_ON" "centerLeft" "R0" "stick" 0.1)
fig = dbCreateRect(layout list(42 -1) list(2.078:0.749 2.408:0.799))
net = dbCreateNet(layout "ENO")
dbCreateTerm( net "ENO" "inputOutput")
dbCreatePin(net fig)
dbCreateLabel(layout list(42 237) 2.078:0.749 "ENO" "centerLeft" "R0" "stick" 0.1)
fig = dbCreateRect(layout list(46 -1) list(0.444:5.651 0.774:5.701))
net = dbCreateNet(layout "CN1")
dbCreateTerm( net "CN1" "inputOutput")
dbCreatePin(net fig)
dbCreateLabel(layout list(46 237) 0.444:5.651 "CN1" "centerLeft" "R0" "stick" 0.1)
mstr = dbOpenCellViewByType( pdkLib "cut_M1M4_2x1" "layout")
layInst=dbCreateInst(layout mstr "" 0.444:5.651 "R0")
fig = dbCreateRect(layout list(46 -1) list(1.476:5.597 1.526:5.927))
net = dbCreateNet(layout "CP1")
dbCreateTerm( net "CP1" "inputOutput")
dbCreatePin(net fig)
dbCreateLabel(layout list(46 237) 1.476:5.597 "CP1" "centerLeft" "R0" "stick" 0.1)
mstr = dbOpenCellViewByType( pdkLib "cut_M1M4_1x2" "layout")
layInst=dbCreateInst(layout mstr "" 1.476:5.597 "R0")
fig = dbCreateRect(layout list(46 -1) list(1.676:6.973 1.726:7.303))
net = dbCreateNet(layout "CP0")
dbCreateTerm( net "CP0" "inputOutput")
dbCreatePin(net fig)
dbCreateLabel(layout list(46 237) 1.676:6.973 "CP0" "centerLeft" "R0" "stick" 0.1)
mstr = dbOpenCellViewByType( pdkLib "cut_M1M4_1x2" "layout")
layInst=dbCreateInst(layout mstr "" 1.676:6.973 "R0")
fig = dbCreateRect(layout list(46 -1) list(1.776:8.349 1.826:8.679))
net = dbCreateNet(layout "CN0")
dbCreateTerm( net "CN0" "inputOutput")
dbCreatePin(net fig)
dbCreateLabel(layout list(46 237) 1.776:8.349 "CN0" "centerLeft" "R0" "stick" 0.1)
mstr = dbOpenCellViewByType( pdkLib "cut_M1M4_1x2" "layout")
layInst=dbCreateInst(layout mstr "" 1.776:8.349 "R0")
mstr = dbOpenCellViewByType( pdkLib "cut_M2M3_2x1" "layout")
layInst=dbCreateInst(layout mstr "" 2.078:0.749 "R0")
mstr = dbOpenCellViewByType( pdkLib "cut_M2M3_2x1" "layout")
layInst=dbCreateInst(layout mstr "" 0.444:0.491 "R0")
mstr = dbOpenCellViewByType( pdkLib "cut_M2M3_2x1" "layout")
layInst=dbCreateInst(layout mstr "" 0.444:0.491 "R0")
mstr = dbOpenCellViewByType( pdkLib "cut_M2M3_2x1" "layout")
layInst=dbCreateInst(layout mstr "" 0.444:2.211 "R0")
mstr = dbOpenCellViewByType( pdkLib "cut_M2M3_2x1" "layout")
layInst=dbCreateInst(layout mstr "" 0.444:2.211 "R0")
fig = dbCreateRect(layout list(34 -1) list(0.43:13.214 0.774:13.274))
net = dbCreateNet(layout "CEIN")
dbCreateTerm( net "CEIN" "inputOutput")
dbCreatePin(net fig)
dbCreateLabel(layout list(34 237) 0.43:13.214 "CEIN" "centerLeft" "R0" "stick" 0.1)
fig = dbCreateRect(layout list(34 -1) list(2.064:13.644 2.408:13.704))
net = dbCreateNet(layout "CEO")
dbCreateTerm( net "CEO" "inputOutput")
dbCreatePin(net fig)
dbCreateLabel(layout list(34 237) 2.064:13.644 "CEO" "centerLeft" "R0" "stick" 0.1)
fig = dbCreateRect(layout list(34 -1) list(0.43:10.118 0.774:10.178))
net = dbCreateNet(layout "CKS")
dbCreateTerm( net "CKS" "inputOutput")
dbCreatePin(net fig)
dbCreateLabel(layout list(34 237) 0.43:10.118 "CKS" "centerLeft" "R0" "stick" 0.1)
fig = dbCreateRect(layout list(34 -1) list(1.032:11.58 1.376:11.64))
net = dbCreateNet(layout "DONE")
dbCreateTerm( net "DONE" "inputOutput")
dbCreatePin(net fig)
dbCreateLabel(layout list(34 237) 1.032:11.58 "DONE" "centerLeft" "R0" "stick" 0.1)
fig = dbCreateRect(layout list(46 -1) list(2.752:4.7 3.082:4.75))
net = dbCreateNet(layout "VREF")
dbCreateTerm( net "VREF" "inputOutput")
dbCreatePin(net fig)
dbCreateLabel(layout list(46 237) 2.752:4.7 "VREF" "centerLeft" "R0" "stick" 0.1)
fig = dbCreateRect(layout list(46 -1) list(2.064:0.0 2.394:14.104))
net = dbCreateNet(layout "AVDD")
dbCreateTerm( net "AVDD" "inputOutput")
dbCreatePin(net fig)
dbCreateLabel(layout list(46 237) 2.064:0.0 "AVDD" "centerLeft" "R0" "stick" 0.1)
fig = dbCreateRect(layout list(46 -1) list(1.032:0.0 1.362:14.104))
net = dbCreateNet(layout "AVSS")
dbCreateTerm( net "AVSS" "inputOutput")
dbCreatePin(net fig)
dbCreateLabel(layout list(46 237) 1.032:0.0 "AVSS" "centerLeft" "R0" "stick" 0.1)
fig = dbCreateRect(layout list(46 -1) list(2.064:0.0 2.394:14.104))
mstr = dbOpenCellViewByType( pdkLib "cut_M1M4_2x1" "layout")
layInst=dbCreateInst(layout mstr "" 1.032:13.988 "R0")
fig = dbCreateRect(layout list(46 -1) list(1.032:0.0 1.362:14.104))
 dbSave(layout) )
