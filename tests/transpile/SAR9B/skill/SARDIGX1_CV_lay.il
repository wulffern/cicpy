gdssLibName = "SAR9B"
 pdkLib = "SAR9B"
;- Create cell SARDIGX1_CV
(let (layout net fig )
 layout = dbOpenCellViewByType(gdssLibName "SARDIGX1_CV" "layout" "maskLayout" "w")
mstr = dbOpenCellViewByType( pdkLib "SARMRYX1_CV" "layout")
layInst=dbCreateInst(layout mstr "XA1" 0.0:0.0 "R0")
mstr = dbOpenCellViewByType( pdkLib "SWX2_CV" "layout")
layInst=dbCreateInst(layout mstr "XA2" 0.0:4.128 "R0")
mstr = dbOpenCellViewByType( pdkLib "SWX2_CV" "layout")
layInst=dbCreateInst(layout mstr "XA3" 0.0:4.816 "R0")
mstr = dbOpenCellViewByType( pdkLib "SWX2_CV" "layout")
layInst=dbCreateInst(layout mstr "XA4" 0.0:5.504 "R0")
mstr = dbOpenCellViewByType( pdkLib "SWX2_CV" "layout")
layInst=dbCreateInst(layout mstr "XA5" 0.0:6.192 "R0")
mstr = dbOpenCellViewByType( pdkLib "TAPCELL_CV" "layout")
layInst=dbCreateInst(layout mstr "XA6" 0.0:6.88 "R0")
fig = dbCreateRect(layout list(34 -1) list(0.602:4.958 0.844:5.018))
fig = dbCreateRect(layout list(34 -1) list(0.844:4.356 1.204:4.416))
fig = dbCreateRect(layout list(34 -1) list(0.844:4.356 0.904:5.018))
dbCreateLabel(layout list(58 -1) 0.43:4.958 "CP0" "centerLeft" "R0" "stick" 0.1)
fig = dbCreateRect(layout list(34 -1) list(0.602:6.334 0.844:6.394))
fig = dbCreateRect(layout list(34 -1) list(0.844:5.732 1.204:5.792))
fig = dbCreateRect(layout list(34 -1) list(0.844:5.732 0.904:6.394))
dbCreateLabel(layout list(58 -1) 0.43:6.334 "CN1" "centerLeft" "R0" "stick" 0.1)
fig = dbCreateRect(layout list(34 -1) list(2.536:4.27 2.838:4.33))
fig = dbCreateRect(layout list(34 -1) list(2.236:4.012 2.536:4.072))
fig = dbCreateRect(layout list(34 -1) list(2.536:4.012 2.596:4.33))
dbCreateLabel(layout list(58 -1) 2.666:4.27 "CHL_OP" "centerLeft" "R0" "stick" 0.1)
mstr = dbOpenCellViewByType( pdkLib "cut_M1M2_2x1" "layout")
layInst=dbCreateInst(layout mstr "" 0.43:5.646 "R0")
mstr = dbOpenCellViewByType( pdkLib "cut_M1M2_2x1" "layout")
layInst=dbCreateInst(layout mstr "" 1.032:2.98 "R0")
fig = dbCreateRect(layout list(36 -1) list(0.602:5.646 0.844:5.706))
fig = dbCreateRect(layout list(36 -1) list(0.844:2.98 1.204:3.04))
fig = dbCreateRect(layout list(36 -1) list(0.844:2.98 0.904:5.706))
dbCreateLabel(layout list(58 -1) 0.43:5.646 "CHL_ON" "centerLeft" "R0" "stick" 0.1)
fig = dbCreateRect(layout list(34 -1) list(0.43:2.206 0.774:2.266))
net = dbCreateNet(layout "CMP_OP")
dbCreateTerm( net "CMP_OP" "inputOutput")
dbCreatePin(net fig)
dbCreateLabel(layout list(34 237) 0.43:2.206 "CMP_OP" "centerLeft" "R0" "stick" 0.1)
fig = dbCreateRect(layout list(34 -1) list(2.666:3.926 3.01:3.986))
net = dbCreateNet(layout "RST_N")
dbCreateTerm( net "RST_N" "inputOutput")
dbCreatePin(net fig)
dbCreateLabel(layout list(34 237) 2.666:3.926 "RST_N" "centerLeft" "R0" "stick" 0.1)
fig = dbCreateRect(layout list(34 -1) list(0.43:0.486 0.774:0.546))
net = dbCreateNet(layout "EN")
dbCreateTerm( net "EN" "inputOutput")
dbCreatePin(net fig)
dbCreateLabel(layout list(34 237) 0.43:0.486 "EN" "centerLeft" "R0" "stick" 0.1)
fig = dbCreateRect(layout list(34 -1) list(0.43:3.238 0.774:3.298))
net = dbCreateNet(layout "CMP_ON")
dbCreateTerm( net "CMP_ON" "inputOutput")
dbCreatePin(net fig)
dbCreateLabel(layout list(34 237) 0.43:3.238 "CMP_ON" "centerLeft" "R0" "stick" 0.1)
fig = dbCreateRect(layout list(34 -1) list(2.064:0.744 2.408:0.804))
net = dbCreateNet(layout "ENO")
dbCreateTerm( net "ENO" "inputOutput")
dbCreatePin(net fig)
dbCreateLabel(layout list(34 237) 2.064:0.744 "ENO" "centerLeft" "R0" "stick" 0.1)
fig = dbCreateRect(layout list(46 -1) list(0.444:4.963 0.774:5.013))
net = dbCreateNet(layout "CN1")
dbCreateTerm( net "CN1" "inputOutput")
dbCreatePin(net fig)
dbCreateLabel(layout list(46 237) 0.444:4.963 "CN1" "centerLeft" "R0" "stick" 0.1)
mstr = dbOpenCellViewByType( pdkLib "cut_M1M4_2x1" "layout")
layInst=dbCreateInst(layout mstr "" 0.444:4.963 "R0")
fig = dbCreateRect(layout list(46 -1) list(1.476:4.909 1.526:5.239))
net = dbCreateNet(layout "CP1")
dbCreateTerm( net "CP1" "inputOutput")
dbCreatePin(net fig)
dbCreateLabel(layout list(46 237) 1.476:4.909 "CP1" "centerLeft" "R0" "stick" 0.1)
mstr = dbOpenCellViewByType( pdkLib "cut_M1M4_1x2" "layout")
layInst=dbCreateInst(layout mstr "" 1.476:4.909 "R0")
fig = dbCreateRect(layout list(46 -1) list(1.676:5.597 1.726:5.927))
net = dbCreateNet(layout "CP0")
dbCreateTerm( net "CP0" "inputOutput")
dbCreatePin(net fig)
dbCreateLabel(layout list(46 237) 1.676:5.597 "CP0" "centerLeft" "R0" "stick" 0.1)
mstr = dbOpenCellViewByType( pdkLib "cut_M1M4_1x2" "layout")
layInst=dbCreateInst(layout mstr "" 1.676:5.597 "R0")
fig = dbCreateRect(layout list(46 -1) list(1.776:6.285 1.826:6.615))
net = dbCreateNet(layout "CN0")
dbCreateTerm( net "CN0" "inputOutput")
dbCreatePin(net fig)
dbCreateLabel(layout list(46 237) 1.776:6.285 "CN0" "centerLeft" "R0" "stick" 0.1)
mstr = dbOpenCellViewByType( pdkLib "cut_M1M4_1x2" "layout")
layInst=dbCreateInst(layout mstr "" 1.776:6.285 "R0")
fig = dbCreateRect(layout list(46 -1) list(2.752:4.7 3.082:4.75))
net = dbCreateNet(layout "VREF")
dbCreateTerm( net "VREF" "inputOutput")
dbCreatePin(net fig)
dbCreateLabel(layout list(46 237) 2.752:4.7 "VREF" "centerLeft" "R0" "stick" 0.1)
fig = dbCreateRect(layout list(46 -1) list(2.064:0.0 2.394:7.224))
net = dbCreateNet(layout "AVDD")
dbCreateTerm( net "AVDD" "inputOutput")
dbCreatePin(net fig)
dbCreateLabel(layout list(46 237) 2.064:0.0 "AVDD" "centerLeft" "R0" "stick" 0.1)
fig = dbCreateRect(layout list(46 -1) list(1.032:0.0 1.362:7.224))
net = dbCreateNet(layout "AVSS")
dbCreateTerm( net "AVSS" "inputOutput")
dbCreatePin(net fig)
dbCreateLabel(layout list(46 237) 1.032:0.0 "AVSS" "centerLeft" "R0" "stick" 0.1)
fig = dbCreateRect(layout list(46 -1) list(2.064:0.0 2.394:7.224))
mstr = dbOpenCellViewByType( pdkLib "cut_M1M4_2x1" "layout")
layInst=dbCreateInst(layout mstr "" 1.032:7.108 "R0")
fig = dbCreateRect(layout list(46 -1) list(1.032:0.0 1.362:7.224))
 dbSave(layout) )
