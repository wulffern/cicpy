gdssLibName = "SAR9B"
 pdkLib = "SAR9B"
;- Create cell ALGIC001_SAR9B_CV
(let (layout net fig )
 layout = dbOpenCellViewByType(gdssLibName "ALGIC001_SAR9B_CV" "layout" "maskLayout" "w")
mstr = dbOpenCellViewByType( pdkLib "SARBSSW_CV" "layout")
layInst=dbCreateInst(layout mstr "XB1" 16.855:0.0 "MY")
mstr = dbOpenCellViewByType( pdkLib "SARBSSW_CV" "layout")
layInst=dbCreateInst(layout mstr "XB2" 16.855:0.0 "R0")
mstr = dbOpenCellViewByType( pdkLib "CDAC9_CV" "layout")
layInst=dbCreateInst(layout mstr "XDAC1" 16.68:3.361 "MY")
mstr = dbOpenCellViewByType( pdkLib "CDAC9_CV" "layout")
layInst=dbCreateInst(layout mstr "XDAC2" 17.03:3.361 "R0")
mstr = dbOpenCellViewByType( pdkLib "SARDIGEX4_CV" "layout")
layInst=dbCreateInst(layout mstr "XA0" -0.345:64.346 "R0")
mstr = dbOpenCellViewByType( pdkLib "SARDIGEX4_CV" "layout")
layInst=dbCreateInst(layout mstr "XA1" 6.535:64.346 "MY")
mstr = dbOpenCellViewByType( pdkLib "SARDIGEX4_CV" "layout")
layInst=dbCreateInst(layout mstr "XA2" 6.535:64.346 "R0")
mstr = dbOpenCellViewByType( pdkLib "SARDIGEX4_CV" "layout")
layInst=dbCreateInst(layout mstr "XA3" 13.415:64.346 "MY")
mstr = dbOpenCellViewByType( pdkLib "SARDIGEX4_CV" "layout")
layInst=dbCreateInst(layout mstr "XA4" 13.415:64.346 "R0")
mstr = dbOpenCellViewByType( pdkLib "SARDIGEX4_CV" "layout")
layInst=dbCreateInst(layout mstr "XA5" 20.295:64.346 "MY")
mstr = dbOpenCellViewByType( pdkLib "SARDIGEX4_CV" "layout")
layInst=dbCreateInst(layout mstr "XA6" 20.295:64.346 "R0")
mstr = dbOpenCellViewByType( pdkLib "SARDIGEX4_CV" "layout")
layInst=dbCreateInst(layout mstr "XA7" 27.175:64.346 "MY")
mstr = dbOpenCellViewByType( pdkLib "SARDIGEX4_CV" "layout")
layInst=dbCreateInst(layout mstr "XA8" 27.175:64.346 "R0")
mstr = dbOpenCellViewByType( pdkLib "SARCMPX1_CV" "layout")
layInst=dbCreateInst(layout mstr "XA20" 34.055:64.346 "MY")
fig = dbCreateRect(layout list(46 -1) list(13.0:55.071 33.79:55.131))
fig = dbCreateRect(layout list(46 -1) list(13.0:55.601 33.79:55.661))
fig = dbCreateRect(layout list(42 -1) list(20.66:54.336 20.72:55.121))
mstr = dbOpenCellViewByType( pdkLib "cut_M3M4_1x2" "layout")
layInst=dbCreateInst(layout mstr "" 20.66:54.336 "R0")
mstr = dbOpenCellViewByType( pdkLib "cut_M3M4_2x1" "layout")
layInst=dbCreateInst(layout mstr "" 20.66:55.071 "R0")
fig = dbCreateRect(layout list(42 -1) list(13.0:54.336 13.06:55.651))
mstr = dbOpenCellViewByType( pdkLib "cut_M3M4_1x2" "layout")
layInst=dbCreateInst(layout mstr "" 13.0:54.336 "R0")
mstr = dbOpenCellViewByType( pdkLib "cut_M3M4_2x1" "layout")
layInst=dbCreateInst(layout mstr "" 13.0:55.601 "R0")
mstr = dbOpenCellViewByType( pdkLib "cut_M2M4_2x1" "layout")
layInst=dbCreateInst(layout mstr "" 33.281:66.552 "R0")
fig = dbCreateRect(layout list(81 -1) list(33.281:55.601 33.341:55.861))
fig = dbCreateRect(layout list(46 -1) list(33.281:55.861 33.341:66.552))
mstr = dbOpenCellViewByType( pdkLib "cut_M4M5_2x1" "layout")
layInst=dbCreateInst(layout mstr "" 33.281:55.601 "R0")
mstr = dbOpenCellViewByType( pdkLib "cut_M4M5_1x2" "layout")
layInst=dbCreateInst(layout mstr "" 33.281:55.861 "R0")
mstr = dbOpenCellViewByType( pdkLib "cut_M3M4_2x1" "layout")
layInst=dbCreateInst(layout mstr "" 33.425:74.12 "R0")
mstr = dbOpenCellViewByType( pdkLib "cut_M2M3_2x1" "layout")
layInst=dbCreateInst(layout mstr "" 33.281:74.12 "R0")
fig = dbCreateRect(layout list(81 -1) list(33.695:55.071 33.755:55.861))
fig = dbCreateRect(layout list(46 -1) list(33.695:55.861 33.755:74.12))
mstr = dbOpenCellViewByType( pdkLib "cut_M4M5_2x1" "layout")
layInst=dbCreateInst(layout mstr "" 33.695:55.071 "R0")
mstr = dbOpenCellViewByType( pdkLib "cut_M4M5_1x2" "layout")
layInst=dbCreateInst(layout mstr "" 33.695:55.861 "R0")
mstr = dbOpenCellViewByType( pdkLib "cut_M3M4_1x2" "layout")
layInst=dbCreateInst(layout mstr "" 0.104:55.996 "R0")
fig = dbCreateRect(layout list(46 -1) list(0.099:56.191 0.159:69.997))
fig = dbCreateRect(layout list(46 -1) list(0.099:56.191 0.159:69.997))
net = dbCreateNet(layout "D<9>")
dbCreateTerm( net "D<9>" "inputOutput")
dbCreatePin(net fig)
dbCreateLabel(layout list(46 237) 0.099:56.191 "D<9>" "centerLeft" "R0" "stick" 1.1)
mstr = dbOpenCellViewByType( pdkLib "cut_M2M3_1x2" "layout")
layInst=dbCreateInst(layout mstr "" 19.755:55.996 "R0")
fig = dbCreateRect(layout list(36 -1) list(19.75:54.276 19.81:56.131))
fig = dbCreateRect(layout list(42 -1) list(0.099:56.131 19.81:56.191))
mstr = dbOpenCellViewByType( pdkLib "cut_M3M4_1x2" "layout")
layInst=dbCreateInst(layout mstr "" 13.864:56.261 "R0")
fig = dbCreateRect(layout list(46 -1) list(13.859:56.456 13.919:69.997))
mstr = dbOpenCellViewByType( pdkLib "cut_M2M3_1x2" "layout")
layInst=dbCreateInst(layout mstr "" 18.155:56.261 "R0")
fig = dbCreateRect(layout list(36 -1) list(18.15:54.276 18.21:56.396))
fig = dbCreateRect(layout list(42 -1) list(13.859:56.396 18.21:56.456))
mstr = dbOpenCellViewByType( pdkLib "cut_M3M4_1x2" "layout")
layInst=dbCreateInst(layout mstr "" 12.646:56.526 "R0")
fig = dbCreateRect(layout list(46 -1) list(12.641:56.721 12.701:69.997))
mstr = dbOpenCellViewByType( pdkLib "cut_M2M3_1x2" "layout")
layInst=dbCreateInst(layout mstr "" 18.555:56.526 "R0")
fig = dbCreateRect(layout list(36 -1) list(18.55:54.276 18.61:56.661))
fig = dbCreateRect(layout list(42 -1) list(12.641:56.661 18.61:56.721))
mstr = dbOpenCellViewByType( pdkLib "cut_M3M4_1x2" "layout")
layInst=dbCreateInst(layout mstr "" 6.984:56.791 "R0")
fig = dbCreateRect(layout list(46 -1) list(6.979:56.986 7.039:69.997))
mstr = dbOpenCellViewByType( pdkLib "cut_M2M3_1x2" "layout")
layInst=dbCreateInst(layout mstr "" 18.955:56.791 "R0")
fig = dbCreateRect(layout list(36 -1) list(18.95:54.276 19.01:56.926))
fig = dbCreateRect(layout list(42 -1) list(6.979:56.926 19.01:56.986))
mstr = dbOpenCellViewByType( pdkLib "cut_M3M4_1x2" "layout")
layInst=dbCreateInst(layout mstr "" 5.766:57.056 "R0")
fig = dbCreateRect(layout list(46 -1) list(5.761:57.251 5.821:69.997))
mstr = dbOpenCellViewByType( pdkLib "cut_M2M3_1x2" "layout")
layInst=dbCreateInst(layout mstr "" 19.355:57.056 "R0")
fig = dbCreateRect(layout list(36 -1) list(19.35:54.276 19.41:57.191))
fig = dbCreateRect(layout list(42 -1) list(5.761:57.191 19.41:57.251))
mstr = dbOpenCellViewByType( pdkLib "cut_M3M4_1x2" "layout")
layInst=dbCreateInst(layout mstr "" 1.136:57.321 "R0")
fig = dbCreateRect(layout list(46 -1) list(1.131:57.516 1.191:69.943))
mstr = dbOpenCellViewByType( pdkLib "cut_M2M3_1x2" "layout")
layInst=dbCreateInst(layout mstr "" 13.905:57.321 "R0")
fig = dbCreateRect(layout list(36 -1) list(13.9:54.276 13.96:57.456))
fig = dbCreateRect(layout list(42 -1) list(1.131:57.456 13.96:57.516))
mstr = dbOpenCellViewByType( pdkLib "cut_M3M4_1x2" "layout")
layInst=dbCreateInst(layout mstr "" 11.894:57.586 "R0")
fig = dbCreateRect(layout list(46 -1) list(11.889:57.781 11.949:69.943))
fig = dbCreateRect(layout list(46 -1) list(11.889:57.781 11.949:69.943))
net = dbCreateNet(layout "D<6>")
dbCreateTerm( net "D<6>" "inputOutput")
dbCreatePin(net fig)
dbCreateLabel(layout list(46 237) 11.889:57.781 "D<6>" "centerLeft" "R0" "stick" 1.1)
mstr = dbOpenCellViewByType( pdkLib "cut_M2M3_1x2" "layout")
layInst=dbCreateInst(layout mstr "" 15.105:57.586 "R0")
fig = dbCreateRect(layout list(36 -1) list(15.1:54.276 15.16:57.721))
fig = dbCreateRect(layout list(42 -1) list(11.889:57.721 15.16:57.781))
mstr = dbOpenCellViewByType( pdkLib "cut_M3M4_1x2" "layout")
layInst=dbCreateInst(layout mstr "" 14.896:57.851 "R0")
fig = dbCreateRect(layout list(46 -1) list(14.891:58.046 14.951:69.943))
fig = dbCreateRect(layout list(46 -1) list(14.891:58.046 14.951:69.943))
net = dbCreateNet(layout "D<5>")
dbCreateTerm( net "D<5>" "inputOutput")
dbCreatePin(net fig)
dbCreateLabel(layout list(46 237) 14.891:58.046 "D<5>" "centerLeft" "R0" "stick" 1.1)
mstr = dbOpenCellViewByType( pdkLib "cut_M2M3_1x2" "layout")
layInst=dbCreateInst(layout mstr "" 15.505:57.851 "R0")
fig = dbCreateRect(layout list(36 -1) list(15.5:54.276 15.56:57.986))
fig = dbCreateRect(layout list(42 -1) list(14.891:57.986 15.56:58.046))
mstr = dbOpenCellViewByType( pdkLib "cut_M3M4_1x2" "layout")
layInst=dbCreateInst(layout mstr "" 18.774:58.116 "R0")
fig = dbCreateRect(layout list(46 -1) list(18.769:58.311 18.829:69.943))
fig = dbCreateRect(layout list(46 -1) list(18.769:58.311 18.829:69.943))
net = dbCreateNet(layout "D<4>")
dbCreateTerm( net "D<4>" "inputOutput")
dbCreatePin(net fig)
dbCreateLabel(layout list(46 237) 18.769:58.311 "D<4>" "centerLeft" "R0" "stick" 1.1)
mstr = dbOpenCellViewByType( pdkLib "cut_M2M3_1x2" "layout")
layInst=dbCreateInst(layout mstr "" 15.905:58.116 "R0")
fig = dbCreateRect(layout list(36 -1) list(15.9:54.276 15.96:58.251))
fig = dbCreateRect(layout list(42 -1) list(15.9:58.251 18.829:58.311))
mstr = dbOpenCellViewByType( pdkLib "cut_M3M4_1x2" "layout")
layInst=dbCreateInst(layout mstr "" 21.776:58.381 "R0")
fig = dbCreateRect(layout list(46 -1) list(21.771:58.576 21.831:69.943))
fig = dbCreateRect(layout list(46 -1) list(21.771:58.576 21.831:69.943))
net = dbCreateNet(layout "D<3>")
dbCreateTerm( net "D<3>" "inputOutput")
dbCreatePin(net fig)
dbCreateLabel(layout list(46 237) 21.771:58.576 "D<3>" "centerLeft" "R0" "stick" 1.1)
mstr = dbOpenCellViewByType( pdkLib "cut_M2M3_1x2" "layout")
layInst=dbCreateInst(layout mstr "" 16.105:58.381 "R0")
fig = dbCreateRect(layout list(36 -1) list(16.1:54.276 16.16:58.516))
fig = dbCreateRect(layout list(42 -1) list(16.1:58.516 21.831:58.576))
mstr = dbOpenCellViewByType( pdkLib "cut_M3M4_1x2" "layout")
layInst=dbCreateInst(layout mstr "" 25.654:58.646 "R0")
fig = dbCreateRect(layout list(46 -1) list(25.649:58.841 25.709:69.943))
fig = dbCreateRect(layout list(46 -1) list(25.649:58.841 25.709:69.943))
net = dbCreateNet(layout "D<2>")
dbCreateTerm( net "D<2>" "inputOutput")
dbCreatePin(net fig)
dbCreateLabel(layout list(46 237) 25.649:58.841 "D<2>" "centerLeft" "R0" "stick" 1.1)
mstr = dbOpenCellViewByType( pdkLib "cut_M2M3_1x2" "layout")
layInst=dbCreateInst(layout mstr "" 16.305:58.646 "R0")
fig = dbCreateRect(layout list(36 -1) list(16.3:54.276 16.36:58.781))
fig = dbCreateRect(layout list(42 -1) list(16.3:58.781 25.709:58.841))
mstr = dbOpenCellViewByType( pdkLib "cut_M3M4_1x2" "layout")
layInst=dbCreateInst(layout mstr "" 28.656:58.911 "R0")
fig = dbCreateRect(layout list(46 -1) list(28.651:59.106 28.711:69.943))
fig = dbCreateRect(layout list(46 -1) list(28.651:59.106 28.711:69.943))
net = dbCreateNet(layout "D<1>")
dbCreateTerm( net "D<1>" "inputOutput")
dbCreatePin(net fig)
dbCreateLabel(layout list(46 237) 28.651:59.106 "D<1>" "centerLeft" "R0" "stick" 1.1)
mstr = dbOpenCellViewByType( pdkLib "cut_M2M3_1x2" "layout")
layInst=dbCreateInst(layout mstr "" 16.505:58.911 "R0")
fig = dbCreateRect(layout list(36 -1) list(16.5:54.276 16.56:59.046))
fig = dbCreateRect(layout list(42 -1) list(16.5:59.046 28.711:59.106))
mstr = dbOpenCellViewByType( pdkLib "cut_M3M4_1x2" "layout")
layInst=dbCreateInst(layout mstr "" 8.016:59.176 "R0")
fig = dbCreateRect(layout list(46 -1) list(8.011:59.371 8.071:69.943))
fig = dbCreateRect(layout list(46 -1) list(8.011:59.371 8.071:69.943))
net = dbCreateNet(layout "D<7>")
dbCreateTerm( net "D<7>" "inputOutput")
dbCreatePin(net fig)
dbCreateLabel(layout list(46 237) 8.011:59.371 "D<7>" "centerLeft" "R0" "stick" 1.1)
mstr = dbOpenCellViewByType( pdkLib "cut_M2M3_1x2" "layout")
layInst=dbCreateInst(layout mstr "" 14.705:59.176 "R0")
fig = dbCreateRect(layout list(36 -1) list(14.7:54.276 14.76:59.311))
fig = dbCreateRect(layout list(42 -1) list(8.011:59.311 14.76:59.371))
mstr = dbOpenCellViewByType( pdkLib "cut_M3M4_1x2" "layout")
layInst=dbCreateInst(layout mstr "" 5.014:59.441 "R0")
fig = dbCreateRect(layout list(46 -1) list(5.009:59.636 5.069:69.943))
fig = dbCreateRect(layout list(46 -1) list(5.009:59.636 5.069:69.943))
net = dbCreateNet(layout "D<8>")
dbCreateTerm( net "D<8>" "inputOutput")
dbCreatePin(net fig)
dbCreateLabel(layout list(46 237) 5.009:59.636 "D<8>" "centerLeft" "R0" "stick" 1.1)
mstr = dbOpenCellViewByType( pdkLib "cut_M2M3_1x2" "layout")
layInst=dbCreateInst(layout mstr "" 14.305:59.441 "R0")
fig = dbCreateRect(layout list(36 -1) list(14.3:54.276 14.36:59.576))
fig = dbCreateRect(layout list(42 -1) list(5.009:59.576 14.36:59.636))
mstr = dbOpenCellViewByType( pdkLib "cut_M3M4_1x2" "layout")
layInst=dbCreateInst(layout mstr "" 11.694:59.706 "R0")
fig = dbCreateRect(layout list(46 -1) list(11.689:59.901 11.749:71.319))
mstr = dbOpenCellViewByType( pdkLib "cut_M2M3_1x2" "layout")
layInst=dbCreateInst(layout mstr "" 15.305:59.706 "R0")
fig = dbCreateRect(layout list(36 -1) list(15.3:54.276 15.36:59.841))
fig = dbCreateRect(layout list(42 -1) list(11.689:59.841 15.36:59.901))
mstr = dbOpenCellViewByType( pdkLib "cut_M3M4_1x2" "layout")
layInst=dbCreateInst(layout mstr "" 15.096:59.971 "R0")
fig = dbCreateRect(layout list(46 -1) list(15.091:60.166 15.151:71.319))
mstr = dbOpenCellViewByType( pdkLib "cut_M2M3_1x2" "layout")
layInst=dbCreateInst(layout mstr "" 15.705:59.971 "R0")
fig = dbCreateRect(layout list(36 -1) list(15.7:54.276 15.76:60.106))
fig = dbCreateRect(layout list(42 -1) list(15.091:60.106 15.76:60.166))
mstr = dbOpenCellViewByType( pdkLib "cut_M3M4_1x2" "layout")
layInst=dbCreateInst(layout mstr "" 8.216:60.236 "R0")
fig = dbCreateRect(layout list(46 -1) list(8.211:60.431 8.271:71.319))
mstr = dbOpenCellViewByType( pdkLib "cut_M2M3_1x2" "layout")
layInst=dbCreateInst(layout mstr "" 14.905:60.236 "R0")
fig = dbCreateRect(layout list(36 -1) list(14.9:54.276 14.96:60.371))
fig = dbCreateRect(layout list(42 -1) list(8.211:60.371 14.96:60.431))
mstr = dbOpenCellViewByType( pdkLib "cut_M3M4_1x2" "layout")
layInst=dbCreateInst(layout mstr "" 4.814:60.501 "R0")
fig = dbCreateRect(layout list(46 -1) list(4.809:60.696 4.869:71.319))
mstr = dbOpenCellViewByType( pdkLib "cut_M2M3_1x2" "layout")
layInst=dbCreateInst(layout mstr "" 14.505:60.501 "R0")
fig = dbCreateRect(layout list(36 -1) list(14.5:54.276 14.56:60.636))
fig = dbCreateRect(layout list(42 -1) list(4.809:60.636 14.56:60.696))
mstr = dbOpenCellViewByType( pdkLib "cut_M3M4_1x2" "layout")
layInst=dbCreateInst(layout mstr "" 1.336:60.766 "R0")
fig = dbCreateRect(layout list(46 -1) list(1.331:60.961 1.391:71.319))
mstr = dbOpenCellViewByType( pdkLib "cut_M2M3_1x2" "layout")
layInst=dbCreateInst(layout mstr "" 14.105:60.766 "R0")
fig = dbCreateRect(layout list(36 -1) list(14.1:54.276 14.16:60.901))
fig = dbCreateRect(layout list(42 -1) list(1.331:60.901 14.16:60.961))
mstr = dbOpenCellViewByType( pdkLib "cut_M3M4_1x2" "layout")
layInst=dbCreateInst(layout mstr "" 1.436:61.031 "R0")
fig = dbCreateRect(layout list(46 -1) list(1.431:61.226 1.491:72.695))
mstr = dbOpenCellViewByType( pdkLib "cut_M2M3_1x2" "layout")
layInst=dbCreateInst(layout mstr "" 19.555:61.031 "R0")
fig = dbCreateRect(layout list(36 -1) list(19.55:54.276 19.61:61.166))
fig = dbCreateRect(layout list(42 -1) list(1.431:61.166 19.61:61.226))
mstr = dbOpenCellViewByType( pdkLib "cut_M3M4_1x2" "layout")
layInst=dbCreateInst(layout mstr "" 4.714:61.296 "R0")
fig = dbCreateRect(layout list(46 -1) list(4.709:61.491 4.769:72.695))
mstr = dbOpenCellViewByType( pdkLib "cut_M2M3_1x2" "layout")
layInst=dbCreateInst(layout mstr "" 19.155:61.296 "R0")
fig = dbCreateRect(layout list(36 -1) list(19.15:54.276 19.21:61.431))
fig = dbCreateRect(layout list(42 -1) list(4.709:61.431 19.21:61.491))
mstr = dbOpenCellViewByType( pdkLib "cut_M3M4_1x2" "layout")
layInst=dbCreateInst(layout mstr "" 8.316:61.561 "R0")
fig = dbCreateRect(layout list(46 -1) list(8.311:61.756 8.371:72.695))
mstr = dbOpenCellViewByType( pdkLib "cut_M2M3_1x2" "layout")
layInst=dbCreateInst(layout mstr "" 18.755:61.561 "R0")
fig = dbCreateRect(layout list(36 -1) list(18.75:54.276 18.81:61.696))
fig = dbCreateRect(layout list(42 -1) list(8.311:61.696 18.81:61.756))
mstr = dbOpenCellViewByType( pdkLib "cut_M3M4_1x2" "layout")
layInst=dbCreateInst(layout mstr "" 11.594:61.826 "R0")
fig = dbCreateRect(layout list(46 -1) list(11.589:62.021 11.649:72.695))
mstr = dbOpenCellViewByType( pdkLib "cut_M2M3_1x2" "layout")
layInst=dbCreateInst(layout mstr "" 18.355:61.826 "R0")
fig = dbCreateRect(layout list(36 -1) list(18.35:54.276 18.41:61.961))
fig = dbCreateRect(layout list(42 -1) list(11.589:61.961 18.41:62.021))
mstr = dbOpenCellViewByType( pdkLib "cut_M3M4_1x2" "layout")
layInst=dbCreateInst(layout mstr "" 15.196:62.091 "R0")
fig = dbCreateRect(layout list(46 -1) list(15.191:62.286 15.251:72.695))
mstr = dbOpenCellViewByType( pdkLib "cut_M2M3_1x2" "layout")
layInst=dbCreateInst(layout mstr "" 17.955:62.091 "R0")
fig = dbCreateRect(layout list(36 -1) list(17.95:54.276 18.01:62.226))
fig = dbCreateRect(layout list(42 -1) list(15.191:62.226 18.01:62.286))
mstr = dbOpenCellViewByType( pdkLib "cut_M3M4_1x2" "layout")
layInst=dbCreateInst(layout mstr "" 18.474:62.356 "R0")
fig = dbCreateRect(layout list(46 -1) list(18.469:62.551 18.529:72.695))
mstr = dbOpenCellViewByType( pdkLib "cut_M2M3_1x2" "layout")
layInst=dbCreateInst(layout mstr "" 17.755:62.356 "R0")
fig = dbCreateRect(layout list(36 -1) list(17.75:54.276 17.81:62.491))
fig = dbCreateRect(layout list(42 -1) list(17.75:62.491 18.529:62.551))
mstr = dbOpenCellViewByType( pdkLib "cut_M3M4_1x2" "layout")
layInst=dbCreateInst(layout mstr "" 22.076:62.621 "R0")
fig = dbCreateRect(layout list(46 -1) list(22.071:62.816 22.131:72.695))
mstr = dbOpenCellViewByType( pdkLib "cut_M2M3_1x2" "layout")
layInst=dbCreateInst(layout mstr "" 17.555:62.621 "R0")
fig = dbCreateRect(layout list(36 -1) list(17.55:54.276 17.61:62.756))
fig = dbCreateRect(layout list(42 -1) list(17.55:62.756 22.131:62.816))
mstr = dbOpenCellViewByType( pdkLib "cut_M3M4_1x2" "layout")
layInst=dbCreateInst(layout mstr "" 25.354:62.886 "R0")
fig = dbCreateRect(layout list(46 -1) list(25.349:63.081 25.409:72.695))
mstr = dbOpenCellViewByType( pdkLib "cut_M2M3_1x2" "layout")
layInst=dbCreateInst(layout mstr "" 17.355:62.886 "R0")
fig = dbCreateRect(layout list(36 -1) list(17.35:54.276 17.41:63.021))
fig = dbCreateRect(layout list(42 -1) list(17.35:63.021 25.409:63.081))
mstr = dbOpenCellViewByType( pdkLib "cut_M3M4_1x2" "layout")
layInst=dbCreateInst(layout mstr "" 28.956:63.151 "R0")
fig = dbCreateRect(layout list(46 -1) list(28.951:63.346 29.011:72.695))
mstr = dbOpenCellViewByType( pdkLib "cut_M2M3_1x2" "layout")
layInst=dbCreateInst(layout mstr "" 17.155:63.151 "R0")
fig = dbCreateRect(layout list(36 -1) list(17.15:54.276 17.21:63.286))
fig = dbCreateRect(layout list(42 -1) list(17.15:63.286 29.011:63.346))
fig = dbCreateRect(layout list(34 -1) list(34.585:-0.86 34.915:80.342))
net = dbCreateNet(layout "AVSS")
dbCreateTerm( net "AVSS" "inputOutput")
dbCreatePin(net fig)
dbCreateLabel(layout list(34 237) 34.585:-0.86 "AVSS" "centerLeft" "R0" "stick" 1.1)
fig = dbCreateRect(layout list(34 -1) list(-1.205:-0.86 34.915:-0.53))
fig = dbCreateRect(layout list(34 -1) list(-1.205:80.012 34.915:80.342))
fig = dbCreateRect(layout list(34 -1) list(-1.205:-0.86 -0.875:80.342))
fig = dbCreateRect(layout list(34 -1) list(34.585:-0.86 34.915:80.342))
fig = dbCreateRect(layout list(46 -1) list(0.687:64.346 1.017:80.342))
mstr = dbOpenCellViewByType( pdkLib "cut_M1M4_2x2" "layout")
layInst=dbCreateInst(layout mstr "" 0.687:80.012 "R0")
fig = dbCreateRect(layout list(46 -1) list(5.173:64.346 5.503:80.342))
mstr = dbOpenCellViewByType( pdkLib "cut_M1M4_2x2" "layout")
layInst=dbCreateInst(layout mstr "" 5.173:80.012 "R0")
fig = dbCreateRect(layout list(46 -1) list(7.567:64.346 7.897:80.342))
mstr = dbOpenCellViewByType( pdkLib "cut_M1M4_2x2" "layout")
layInst=dbCreateInst(layout mstr "" 7.567:80.012 "R0")
fig = dbCreateRect(layout list(46 -1) list(12.053:64.346 12.383:80.342))
mstr = dbOpenCellViewByType( pdkLib "cut_M1M4_2x2" "layout")
layInst=dbCreateInst(layout mstr "" 12.053:80.012 "R0")
fig = dbCreateRect(layout list(46 -1) list(14.447:64.346 14.777:80.342))
mstr = dbOpenCellViewByType( pdkLib "cut_M1M4_2x2" "layout")
layInst=dbCreateInst(layout mstr "" 14.447:80.012 "R0")
fig = dbCreateRect(layout list(46 -1) list(18.933:64.346 19.263:80.342))
mstr = dbOpenCellViewByType( pdkLib "cut_M1M4_2x2" "layout")
layInst=dbCreateInst(layout mstr "" 18.933:80.012 "R0")
fig = dbCreateRect(layout list(46 -1) list(21.327:64.346 21.657:80.342))
mstr = dbOpenCellViewByType( pdkLib "cut_M1M4_2x2" "layout")
layInst=dbCreateInst(layout mstr "" 21.327:80.012 "R0")
fig = dbCreateRect(layout list(46 -1) list(25.813:64.346 26.143:80.342))
mstr = dbOpenCellViewByType( pdkLib "cut_M1M4_2x2" "layout")
layInst=dbCreateInst(layout mstr "" 25.813:80.012 "R0")
fig = dbCreateRect(layout list(46 -1) list(28.207:64.346 28.537:80.342))
mstr = dbOpenCellViewByType( pdkLib "cut_M1M4_2x2" "layout")
layInst=dbCreateInst(layout mstr "" 28.207:80.012 "R0")
fig = dbCreateRect(layout list(46 -1) list(32.693:64.346 33.023:80.342))
mstr = dbOpenCellViewByType( pdkLib "cut_M1M4_2x2" "layout")
layInst=dbCreateInst(layout mstr "" 32.693:80.012 "R0")
fig = dbCreateRect(layout list(46 -1) list(13.773:-0.86 14.103:3.096))
mstr = dbOpenCellViewByType( pdkLib "cut_M1M4_2x2" "layout")
layInst=dbCreateInst(layout mstr "" 13.773:-0.86 "R0")
fig = dbCreateRect(layout list(46 -1) list(19.607:-0.86 19.937:3.096))
mstr = dbOpenCellViewByType( pdkLib "cut_M1M4_2x2" "layout")
layInst=dbCreateInst(layout mstr "" 19.607:-0.86 "R0")
fig = dbCreateRect(layout list(34 -1) list(35.445:-1.72 35.775:81.202))
net = dbCreateNet(layout "AVDD")
dbCreateTerm( net "AVDD" "inputOutput")
dbCreatePin(net fig)
dbCreateLabel(layout list(34 237) 35.445:-1.72 "AVDD" "centerLeft" "R0" "stick" 1.1)
fig = dbCreateRect(layout list(34 -1) list(-2.065:-1.72 35.775:-1.39))
fig = dbCreateRect(layout list(34 -1) list(-2.065:80.872 35.775:81.202))
fig = dbCreateRect(layout list(34 -1) list(-2.065:-1.72 -1.735:81.202))
fig = dbCreateRect(layout list(34 -1) list(35.445:-1.72 35.775:81.202))
fig = dbCreateRect(layout list(46 -1) list(1.719:64.346 2.049:81.202))
mstr = dbOpenCellViewByType( pdkLib "cut_M1M4_2x2" "layout")
layInst=dbCreateInst(layout mstr "" 1.719:80.872 "R0")
fig = dbCreateRect(layout list(46 -1) list(4.141:64.346 4.471:81.202))
mstr = dbOpenCellViewByType( pdkLib "cut_M1M4_2x2" "layout")
layInst=dbCreateInst(layout mstr "" 4.141:80.872 "R0")
fig = dbCreateRect(layout list(46 -1) list(8.599:64.346 8.929:81.202))
mstr = dbOpenCellViewByType( pdkLib "cut_M1M4_2x2" "layout")
layInst=dbCreateInst(layout mstr "" 8.599:80.872 "R0")
fig = dbCreateRect(layout list(46 -1) list(11.021:64.346 11.351:81.202))
mstr = dbOpenCellViewByType( pdkLib "cut_M1M4_2x2" "layout")
layInst=dbCreateInst(layout mstr "" 11.021:80.872 "R0")
fig = dbCreateRect(layout list(46 -1) list(15.479:64.346 15.809:81.202))
mstr = dbOpenCellViewByType( pdkLib "cut_M1M4_2x2" "layout")
layInst=dbCreateInst(layout mstr "" 15.479:80.872 "R0")
fig = dbCreateRect(layout list(46 -1) list(17.901:64.346 18.231:81.202))
mstr = dbOpenCellViewByType( pdkLib "cut_M1M4_2x2" "layout")
layInst=dbCreateInst(layout mstr "" 17.901:80.872 "R0")
fig = dbCreateRect(layout list(46 -1) list(22.359:64.346 22.689:81.202))
mstr = dbOpenCellViewByType( pdkLib "cut_M1M4_2x2" "layout")
layInst=dbCreateInst(layout mstr "" 22.359:80.872 "R0")
fig = dbCreateRect(layout list(46 -1) list(24.781:64.346 25.111:81.202))
mstr = dbOpenCellViewByType( pdkLib "cut_M1M4_2x2" "layout")
layInst=dbCreateInst(layout mstr "" 24.781:80.872 "R0")
fig = dbCreateRect(layout list(46 -1) list(29.239:64.346 29.569:81.202))
mstr = dbOpenCellViewByType( pdkLib "cut_M1M4_2x2" "layout")
layInst=dbCreateInst(layout mstr "" 29.239:80.872 "R0")
fig = dbCreateRect(layout list(46 -1) list(31.661:64.346 31.991:81.202))
mstr = dbOpenCellViewByType( pdkLib "cut_M1M4_2x2" "layout")
layInst=dbCreateInst(layout mstr "" 31.661:80.872 "R0")
fig = dbCreateRect(layout list(46 -1) list(12.741:-1.72 13.071:3.096))
mstr = dbOpenCellViewByType( pdkLib "cut_M1M4_2x2" "layout")
layInst=dbCreateInst(layout mstr "" 12.741:-1.72 "R0")
fig = dbCreateRect(layout list(46 -1) list(20.639:-1.72 20.969:3.096))
mstr = dbOpenCellViewByType( pdkLib "cut_M1M4_2x2" "layout")
layInst=dbCreateInst(layout mstr "" 20.639:-1.72 "R0")
fig = dbCreateRect(layout list(34 -1) list(-2.065:81.732 35.775:82.062))
net = dbCreateNet(layout "VREF")
dbCreateTerm( net "VREF" "inputOutput")
dbCreatePin(net fig)
dbCreateLabel(layout list(34 237) -2.065:81.732 "VREF" "centerLeft" "R0" "stick" 1.1)
fig = dbCreateRect(layout list(34 -1) list(-2.065:81.732 35.775:82.062))
fig = dbCreateRect(layout list(46 -1) list(2.407:69.046 2.737:82.062))
mstr = dbOpenCellViewByType( pdkLib "cut_M1M4_2x2" "layout")
layInst=dbCreateInst(layout mstr "" 2.407:81.732 "R0")
fig = dbCreateRect(layout list(46 -1) list(3.453:69.046 3.783:82.062))
mstr = dbOpenCellViewByType( pdkLib "cut_M1M4_2x2" "layout")
layInst=dbCreateInst(layout mstr "" 3.453:81.732 "R0")
fig = dbCreateRect(layout list(46 -1) list(9.287:69.046 9.617:82.062))
mstr = dbOpenCellViewByType( pdkLib "cut_M1M4_2x2" "layout")
layInst=dbCreateInst(layout mstr "" 9.287:81.732 "R0")
fig = dbCreateRect(layout list(46 -1) list(10.333:69.046 10.663:82.062))
mstr = dbOpenCellViewByType( pdkLib "cut_M1M4_2x2" "layout")
layInst=dbCreateInst(layout mstr "" 10.333:81.732 "R0")
fig = dbCreateRect(layout list(46 -1) list(16.167:69.046 16.497:82.062))
mstr = dbOpenCellViewByType( pdkLib "cut_M1M4_2x2" "layout")
layInst=dbCreateInst(layout mstr "" 16.167:81.732 "R0")
fig = dbCreateRect(layout list(46 -1) list(17.213:69.046 17.543:82.062))
mstr = dbOpenCellViewByType( pdkLib "cut_M1M4_2x2" "layout")
layInst=dbCreateInst(layout mstr "" 17.213:81.732 "R0")
fig = dbCreateRect(layout list(46 -1) list(23.047:69.046 23.377:82.062))
mstr = dbOpenCellViewByType( pdkLib "cut_M1M4_2x2" "layout")
layInst=dbCreateInst(layout mstr "" 23.047:81.732 "R0")
fig = dbCreateRect(layout list(46 -1) list(24.093:69.046 24.423:82.062))
mstr = dbOpenCellViewByType( pdkLib "cut_M1M4_2x2" "layout")
layInst=dbCreateInst(layout mstr "" 24.093:81.732 "R0")
fig = dbCreateRect(layout list(46 -1) list(29.927:69.046 30.257:82.062))
mstr = dbOpenCellViewByType( pdkLib "cut_M1M4_2x2" "layout")
layInst=dbCreateInst(layout mstr "" 29.927:81.732 "R0")
fig = dbCreateRect(layout list(34 -1) list(35.947:-1.952 36.007:82.062))
net = dbCreateNet(layout "CK_SAMPLE_BSSW")
dbCreateTerm( net "CK_SAMPLE_BSSW" "inputOutput")
dbCreatePin(net fig)
dbCreateLabel(layout list(34 237) 35.947:-1.952 "CK_SAMPLE_BSSW" "centerLeft" "R0" "stick" 1.1)
fig = dbCreateRect(layout list(34 -1) list(-2.065:-1.952 36.007:-1.892))
fig = dbCreateRect(layout list(34 -1) list(35.947:-1.952 36.007:82.062))
mstr = dbOpenCellViewByType( pdkLib "cut_M1M2_2x1" "layout")
layInst=dbCreateInst(layout mstr "" 14.368:0.142 "R0")
mstr = dbOpenCellViewByType( pdkLib "cut_M1M2_2x1" "layout")
layInst=dbCreateInst(layout mstr "" 14.368:-1.952 "R0")
fig = dbCreateRect(layout list(36 -1) list(14.503:-1.952 14.563:0.202))
dbCreateLabel(layout list(58 -1) 14.361:0.142 "CK_SAMPLE_BSSW" "centerLeft" "R0" "stick" 0.1)
mstr = dbOpenCellViewByType( pdkLib "cut_M1M2_2x1" "layout")
layInst=dbCreateInst(layout mstr "" 19.012:0.142 "R0")
mstr = dbOpenCellViewByType( pdkLib "cut_M1M2_2x1" "layout")
layInst=dbCreateInst(layout mstr "" 19.012:-1.952 "R0")
fig = dbCreateRect(layout list(36 -1) list(19.147:-1.952 19.207:0.202))
dbCreateLabel(layout list(58 -1) 19.005:0.142 "CK_SAMPLE_BSSW" "centerLeft" "R0" "stick" 0.1)
fig = dbCreateRect(layout list(34 -1) list(-2.297:-2.184 36.007:-2.124))
fig = dbCreateRect(layout list(34 -1) list(-2.297:-2.184 -2.237:82.062))
mstr = dbOpenCellViewByType( pdkLib "cut_M1M2_2x1" "layout")
layInst=dbCreateInst(layout mstr "" 0.085:77.56 "R0")
mstr = dbOpenCellViewByType( pdkLib "cut_M1M2_1x2" "layout")
layInst=dbCreateInst(layout mstr "" -2.292:77.425 "R0")
fig = dbCreateRect(layout list(36 -1) list(-2.237:77.56 0.085:77.62))
dbCreateLabel(layout list(58 -1) 0.085:77.56 "CEIN" "centerLeft" "R0" "stick" 0.1)
mstr = dbOpenCellViewByType( pdkLib "cut_M1M4_2x1" "layout")
layInst=dbCreateInst(layout mstr "" 14.749:-2.184 "R0")
fig = dbCreateRect(layout list(46 -1) list(14.884:-2.184 14.944:2.691))
dbCreateLabel(layout list(58 -1) 14.749:2.641 "CEIN" "centerLeft" "R0" "stick" 0.1)
mstr = dbOpenCellViewByType( pdkLib "cut_M1M4_2x1" "layout")
layInst=dbCreateInst(layout mstr "" 18.631:-2.184 "R0")
fig = dbCreateRect(layout list(46 -1) list(18.766:-2.184 18.826:2.691))
dbCreateLabel(layout list(58 -1) 18.631:2.641 "CEIN" "centerLeft" "R0" "stick" 0.1)
mstr = dbOpenCellViewByType( pdkLib "cut_M1M3_2x1" "layout")
layInst=dbCreateInst(layout mstr "" 1.719:77.99 "R0")
mstr = dbOpenCellViewByType( pdkLib "cut_M1M3_2x1" "layout")
layInst=dbCreateInst(layout mstr "" 5.761:77.56 "R0")
fig = dbCreateRect(layout list(42 -1) list(1.719:77.99 2.203:78.05))
fig = dbCreateRect(layout list(42 -1) list(2.203:77.43 5.761:77.49))
fig = dbCreateRect(layout list(42 -1) list(5.701:77.43 5.761:77.62))
fig = dbCreateRect(layout list(42 -1) list(2.203:77.43 2.263:78.05))
dbCreateLabel(layout list(58 -1) 1.719:77.99 "CEO0" "centerLeft" "R0" "stick" 0.1)
mstr = dbOpenCellViewByType( pdkLib "cut_M1M3_2x1" "layout")
layInst=dbCreateInst(layout mstr "" 8.599:77.99 "R0")
mstr = dbOpenCellViewByType( pdkLib "cut_M1M3_2x1" "layout")
layInst=dbCreateInst(layout mstr "" 12.641:77.56 "R0")
fig = dbCreateRect(layout list(42 -1) list(8.599:77.99 9.083:78.05))
fig = dbCreateRect(layout list(42 -1) list(9.083:77.43 12.641:77.49))
fig = dbCreateRect(layout list(42 -1) list(12.581:77.43 12.641:77.62))
fig = dbCreateRect(layout list(42 -1) list(9.083:77.43 9.143:78.05))
dbCreateLabel(layout list(58 -1) 8.599:77.99 "CEO2" "centerLeft" "R0" "stick" 0.1)
mstr = dbOpenCellViewByType( pdkLib "cut_M1M3_2x1" "layout")
layInst=dbCreateInst(layout mstr "" 15.479:77.99 "R0")
mstr = dbOpenCellViewByType( pdkLib "cut_M1M3_2x1" "layout")
layInst=dbCreateInst(layout mstr "" 19.521:77.56 "R0")
fig = dbCreateRect(layout list(42 -1) list(15.479:77.99 15.963:78.05))
fig = dbCreateRect(layout list(42 -1) list(15.963:77.43 19.521:77.49))
fig = dbCreateRect(layout list(42 -1) list(19.461:77.43 19.521:77.62))
fig = dbCreateRect(layout list(42 -1) list(15.963:77.43 16.023:78.05))
dbCreateLabel(layout list(58 -1) 15.479:77.99 "CEO4" "centerLeft" "R0" "stick" 0.1)
mstr = dbOpenCellViewByType( pdkLib "cut_M1M3_2x1" "layout")
layInst=dbCreateInst(layout mstr "" 22.359:77.99 "R0")
mstr = dbOpenCellViewByType( pdkLib "cut_M1M3_2x1" "layout")
layInst=dbCreateInst(layout mstr "" 26.401:77.56 "R0")
fig = dbCreateRect(layout list(42 -1) list(22.359:77.99 22.843:78.05))
fig = dbCreateRect(layout list(42 -1) list(22.843:77.43 26.401:77.49))
fig = dbCreateRect(layout list(42 -1) list(26.341:77.43 26.401:77.62))
fig = dbCreateRect(layout list(42 -1) list(22.843:77.43 22.903:78.05))
dbCreateLabel(layout list(58 -1) 22.359:77.99 "CEO6" "centerLeft" "R0" "stick" 0.1)
mstr = dbOpenCellViewByType( pdkLib "cut_M1M3_2x1" "layout")
layInst=dbCreateInst(layout mstr "" 0.085:74.464 "R0")
mstr = dbOpenCellViewByType( pdkLib "cut_M1M3_2x1" "layout")
layInst=dbCreateInst(layout mstr "" 5.761:74.464 "R0")
mstr = dbOpenCellViewByType( pdkLib "cut_M1M3_2x1" "layout")
layInst=dbCreateInst(layout mstr "" 6.965:74.464 "R0")
mstr = dbOpenCellViewByType( pdkLib "cut_M1M3_2x1" "layout")
layInst=dbCreateInst(layout mstr "" 12.641:74.464 "R0")
mstr = dbOpenCellViewByType( pdkLib "cut_M1M3_2x1" "layout")
layInst=dbCreateInst(layout mstr "" 13.845:74.464 "R0")
mstr = dbOpenCellViewByType( pdkLib "cut_M1M3_2x1" "layout")
layInst=dbCreateInst(layout mstr "" 19.521:74.464 "R0")
mstr = dbOpenCellViewByType( pdkLib "cut_M1M3_2x1" "layout")
layInst=dbCreateInst(layout mstr "" 20.725:74.464 "R0")
mstr = dbOpenCellViewByType( pdkLib "cut_M1M3_2x1" "layout")
layInst=dbCreateInst(layout mstr "" 26.401:74.464 "R0")
mstr = dbOpenCellViewByType( pdkLib "cut_M1M3_2x1" "layout")
layInst=dbCreateInst(layout mstr "" 27.605:74.464 "R0")
fig = dbCreateRect(layout list(42 -1) list(0.369:74.404 0.499:74.464))
fig = dbCreateRect(layout list(42 -1) list(0.499:74.404 5.821:74.464))
fig = dbCreateRect(layout list(42 -1) list(0.499:74.404 7.025:74.464))
fig = dbCreateRect(layout list(42 -1) list(0.499:74.404 12.701:74.464))
fig = dbCreateRect(layout list(42 -1) list(0.499:74.404 13.905:74.464))
fig = dbCreateRect(layout list(42 -1) list(0.499:74.404 19.581:74.464))
fig = dbCreateRect(layout list(42 -1) list(0.499:74.404 20.785:74.464))
fig = dbCreateRect(layout list(42 -1) list(0.499:74.404 26.461:74.464))
fig = dbCreateRect(layout list(42 -1) list(0.499:74.404 27.665:74.464))
fig = dbCreateRect(layout list(42 -1) list(0.257:74.464 0.429:74.524))
fig = dbCreateRect(layout list(42 -1) list(5.761:74.464 5.933:74.524))
fig = dbCreateRect(layout list(42 -1) list(6.965:74.464 7.137:74.524))
fig = dbCreateRect(layout list(42 -1) list(12.641:74.464 12.813:74.524))
fig = dbCreateRect(layout list(42 -1) list(13.845:74.464 14.017:74.524))
fig = dbCreateRect(layout list(42 -1) list(19.521:74.464 19.693:74.524))
fig = dbCreateRect(layout list(42 -1) list(20.725:74.464 20.897:74.524))
fig = dbCreateRect(layout list(42 -1) list(26.401:74.464 26.573:74.524))
fig = dbCreateRect(layout list(42 -1) list(27.605:74.464 27.777:74.524))
dbCreateLabel(layout list(58 -1) 0.085:74.464 "CK_SAMPLE" "centerLeft" "R0" "stick" 0.1)
mstr = dbOpenCellViewByType( pdkLib "cut_M1M2_2x1" "layout")
layInst=dbCreateInst(layout mstr "" 4.127:77.99 "R0")
mstr = dbOpenCellViewByType( pdkLib "cut_M1M2_2x1" "layout")
layInst=dbCreateInst(layout mstr "" 6.965:77.56 "R0")
fig = dbCreateRect(layout list(36 -1) list(4.127:77.99 4.611:78.05))
fig = dbCreateRect(layout list(36 -1) list(4.611:77.43 6.965:77.49))
fig = dbCreateRect(layout list(36 -1) list(6.905:77.43 6.965:77.62))
fig = dbCreateRect(layout list(36 -1) list(4.611:77.43 4.671:78.05))
dbCreateLabel(layout list(58 -1) 4.127:77.99 "CEO1" "centerLeft" "R0" "stick" 0.1)
mstr = dbOpenCellViewByType( pdkLib "cut_M1M2_2x1" "layout")
layInst=dbCreateInst(layout mstr "" 11.007:77.99 "R0")
mstr = dbOpenCellViewByType( pdkLib "cut_M1M2_2x1" "layout")
layInst=dbCreateInst(layout mstr "" 13.845:77.56 "R0")
fig = dbCreateRect(layout list(36 -1) list(11.007:77.99 11.491:78.05))
fig = dbCreateRect(layout list(36 -1) list(11.491:77.43 13.845:77.49))
fig = dbCreateRect(layout list(36 -1) list(13.785:77.43 13.845:77.62))
fig = dbCreateRect(layout list(36 -1) list(11.491:77.43 11.551:78.05))
dbCreateLabel(layout list(58 -1) 11.007:77.99 "CEO3" "centerLeft" "R0" "stick" 0.1)
mstr = dbOpenCellViewByType( pdkLib "cut_M1M2_2x1" "layout")
layInst=dbCreateInst(layout mstr "" 17.887:77.99 "R0")
mstr = dbOpenCellViewByType( pdkLib "cut_M1M2_2x1" "layout")
layInst=dbCreateInst(layout mstr "" 20.725:77.56 "R0")
fig = dbCreateRect(layout list(36 -1) list(17.887:77.99 18.371:78.05))
fig = dbCreateRect(layout list(36 -1) list(18.371:77.43 20.725:77.49))
fig = dbCreateRect(layout list(36 -1) list(20.665:77.43 20.725:77.62))
fig = dbCreateRect(layout list(36 -1) list(18.371:77.43 18.431:78.05))
dbCreateLabel(layout list(58 -1) 17.887:77.99 "CEO5" "centerLeft" "R0" "stick" 0.1)
mstr = dbOpenCellViewByType( pdkLib "cut_M1M2_2x1" "layout")
layInst=dbCreateInst(layout mstr "" 24.767:77.99 "R0")
mstr = dbOpenCellViewByType( pdkLib "cut_M1M2_2x1" "layout")
layInst=dbCreateInst(layout mstr "" 27.605:77.56 "R0")
fig = dbCreateRect(layout list(36 -1) list(24.767:77.99 25.251:78.05))
fig = dbCreateRect(layout list(36 -1) list(25.251:77.43 27.605:77.49))
fig = dbCreateRect(layout list(36 -1) list(27.545:77.43 27.605:77.62))
fig = dbCreateRect(layout list(36 -1) list(25.251:77.43 25.311:78.05))
dbCreateLabel(layout list(58 -1) 24.767:77.99 "CEO7" "centerLeft" "R0" "stick" 0.1)
fig = dbCreateRect(layout list(42 -1) list(1.733:65.095 2.203:65.155))
fig = dbCreateRect(layout list(42 -1) list(2.203:64.707 5.761:64.767))
fig = dbCreateRect(layout list(42 -1) list(5.701:64.707 5.761:64.887))
fig = dbCreateRect(layout list(42 -1) list(2.203:64.707 2.263:65.155))
dbCreateLabel(layout list(58 -1) 1.733:65.095 "ENO0" "centerLeft" "R0" "stick" 0.1)
fig = dbCreateRect(layout list(42 -1) list(8.613:65.095 9.083:65.155))
fig = dbCreateRect(layout list(42 -1) list(9.083:64.707 12.641:64.767))
fig = dbCreateRect(layout list(42 -1) list(12.581:64.707 12.641:64.887))
fig = dbCreateRect(layout list(42 -1) list(9.083:64.707 9.143:65.155))
dbCreateLabel(layout list(58 -1) 8.613:65.095 "ENO2" "centerLeft" "R0" "stick" 0.1)
fig = dbCreateRect(layout list(42 -1) list(15.493:65.095 15.963:65.155))
fig = dbCreateRect(layout list(42 -1) list(15.963:64.707 19.521:64.767))
fig = dbCreateRect(layout list(42 -1) list(19.461:64.707 19.521:64.887))
fig = dbCreateRect(layout list(42 -1) list(15.963:64.707 16.023:65.155))
dbCreateLabel(layout list(58 -1) 15.493:65.095 "ENO4" "centerLeft" "R0" "stick" 0.1)
fig = dbCreateRect(layout list(42 -1) list(22.373:65.095 22.843:65.155))
fig = dbCreateRect(layout list(42 -1) list(22.843:64.707 26.401:64.767))
fig = dbCreateRect(layout list(42 -1) list(26.341:64.707 26.401:64.887))
fig = dbCreateRect(layout list(42 -1) list(22.843:64.707 22.903:65.155))
dbCreateLabel(layout list(58 -1) 22.373:65.095 "ENO6" "centerLeft" "R0" "stick" 0.1)
fig = dbCreateRect(layout list(42 -1) list(29.253:65.095 29.723:65.155))
fig = dbCreateRect(layout list(42 -1) list(29.723:65.095 29.783:65.155))
dbCreateLabel(layout list(58 -1) 29.253:65.095 "ENO8" "centerLeft" "R0" "stick" 0.1)
fig = dbCreateRect(layout list(42 -1) list(4.127:65.095 4.597:65.155))
fig = dbCreateRect(layout list(42 -1) list(4.597:65.095 4.657:65.225))
fig = dbCreateRect(layout list(42 -1) list(4.597:65.225 6.979:65.285))
fig = dbCreateRect(layout list(42 -1) list(6.919:64.837 6.979:65.285))
dbCreateLabel(layout list(58 -1) 4.127:65.095 "ENO1" "centerLeft" "R0" "stick" 0.1)
fig = dbCreateRect(layout list(42 -1) list(11.007:65.095 11.477:65.155))
fig = dbCreateRect(layout list(42 -1) list(11.477:65.095 11.537:65.225))
fig = dbCreateRect(layout list(42 -1) list(11.477:65.225 13.859:65.285))
fig = dbCreateRect(layout list(42 -1) list(13.799:64.837 13.859:65.285))
dbCreateLabel(layout list(58 -1) 11.007:65.095 "ENO3" "centerLeft" "R0" "stick" 0.1)
fig = dbCreateRect(layout list(42 -1) list(17.887:65.095 18.357:65.155))
fig = dbCreateRect(layout list(42 -1) list(18.357:65.095 18.417:65.225))
fig = dbCreateRect(layout list(42 -1) list(18.357:65.225 20.739:65.285))
fig = dbCreateRect(layout list(42 -1) list(20.679:64.837 20.739:65.285))
dbCreateLabel(layout list(58 -1) 17.887:65.095 "ENO5" "centerLeft" "R0" "stick" 0.1)
fig = dbCreateRect(layout list(42 -1) list(24.767:65.095 25.237:65.155))
fig = dbCreateRect(layout list(42 -1) list(25.237:65.095 25.297:65.225))
fig = dbCreateRect(layout list(42 -1) list(25.237:65.225 27.619:65.285))
fig = dbCreateRect(layout list(42 -1) list(27.559:64.837 27.619:65.285))
dbCreateLabel(layout list(58 -1) 24.767:65.095 "ENO7" "centerLeft" "R0" "stick" 0.1)
fig = dbCreateRect(layout list(42 -1) list(0.369:66.617 0.499:66.677))
fig = dbCreateRect(layout list(42 -1) list(0.499:66.617 5.821:66.677))
fig = dbCreateRect(layout list(42 -1) list(0.499:66.617 7.039:66.677))
fig = dbCreateRect(layout list(42 -1) list(0.499:66.617 12.701:66.677))
fig = dbCreateRect(layout list(42 -1) list(0.499:66.617 13.919:66.677))
fig = dbCreateRect(layout list(42 -1) list(0.499:66.617 19.581:66.677))
fig = dbCreateRect(layout list(42 -1) list(0.499:66.617 20.799:66.677))
fig = dbCreateRect(layout list(42 -1) list(0.499:66.617 26.461:66.677))
fig = dbCreateRect(layout list(42 -1) list(0.499:66.617 27.679:66.677))
fig = dbCreateRect(layout list(42 -1) list(0.264:66.557 0.429:66.617))
fig = dbCreateRect(layout list(42 -1) list(5.761:66.557 5.926:66.617))
fig = dbCreateRect(layout list(42 -1) list(6.979:66.557 7.144:66.617))
fig = dbCreateRect(layout list(42 -1) list(12.641:66.557 12.806:66.617))
fig = dbCreateRect(layout list(42 -1) list(13.859:66.557 14.024:66.617))
fig = dbCreateRect(layout list(42 -1) list(19.521:66.557 19.686:66.617))
fig = dbCreateRect(layout list(42 -1) list(20.739:66.557 20.904:66.617))
fig = dbCreateRect(layout list(42 -1) list(26.401:66.557 26.566:66.617))
fig = dbCreateRect(layout list(42 -1) list(27.619:66.557 27.784:66.617))
dbCreateLabel(layout list(58 -1) 0.099:66.557 "CMP_OP" "centerLeft" "R0" "stick" 0.1)
mstr = dbOpenCellViewByType( pdkLib "cut_M1M3_2x1" "layout")
layInst=dbCreateInst(layout mstr "" 0.085:67.584 "R0")
mstr = dbOpenCellViewByType( pdkLib "cut_M1M3_2x1" "layout")
layInst=dbCreateInst(layout mstr "" 5.761:67.584 "R0")
mstr = dbOpenCellViewByType( pdkLib "cut_M1M3_2x1" "layout")
layInst=dbCreateInst(layout mstr "" 6.965:67.584 "R0")
mstr = dbOpenCellViewByType( pdkLib "cut_M1M3_2x1" "layout")
layInst=dbCreateInst(layout mstr "" 12.641:67.584 "R0")
mstr = dbOpenCellViewByType( pdkLib "cut_M1M3_2x1" "layout")
layInst=dbCreateInst(layout mstr "" 13.845:67.584 "R0")
mstr = dbOpenCellViewByType( pdkLib "cut_M1M3_2x1" "layout")
layInst=dbCreateInst(layout mstr "" 19.521:67.584 "R0")
mstr = dbOpenCellViewByType( pdkLib "cut_M1M3_2x1" "layout")
layInst=dbCreateInst(layout mstr "" 20.725:67.584 "R0")
mstr = dbOpenCellViewByType( pdkLib "cut_M1M3_2x1" "layout")
layInst=dbCreateInst(layout mstr "" 26.401:67.584 "R0")
mstr = dbOpenCellViewByType( pdkLib "cut_M1M3_2x1" "layout")
layInst=dbCreateInst(layout mstr "" 27.605:67.584 "R0")
fig = dbCreateRect(layout list(42 -1) list(0.369:67.644 0.499:67.704))
fig = dbCreateRect(layout list(42 -1) list(0.499:67.644 5.821:67.704))
fig = dbCreateRect(layout list(42 -1) list(0.499:67.644 7.025:67.704))
fig = dbCreateRect(layout list(42 -1) list(0.499:67.644 12.701:67.704))
fig = dbCreateRect(layout list(42 -1) list(0.499:67.644 13.905:67.704))
fig = dbCreateRect(layout list(42 -1) list(0.499:67.644 19.581:67.704))
fig = dbCreateRect(layout list(42 -1) list(0.499:67.644 20.785:67.704))
fig = dbCreateRect(layout list(42 -1) list(0.499:67.644 26.461:67.704))
fig = dbCreateRect(layout list(42 -1) list(0.499:67.644 27.665:67.704))
fig = dbCreateRect(layout list(42 -1) list(0.257:67.584 0.429:67.644))
fig = dbCreateRect(layout list(42 -1) list(5.761:67.584 5.933:67.644))
fig = dbCreateRect(layout list(42 -1) list(6.965:67.584 7.137:67.644))
fig = dbCreateRect(layout list(42 -1) list(12.641:67.584 12.813:67.644))
fig = dbCreateRect(layout list(42 -1) list(13.845:67.584 14.017:67.644))
fig = dbCreateRect(layout list(42 -1) list(19.521:67.584 19.693:67.644))
fig = dbCreateRect(layout list(42 -1) list(20.725:67.584 20.897:67.644))
fig = dbCreateRect(layout list(42 -1) list(26.401:67.584 26.573:67.644))
fig = dbCreateRect(layout list(42 -1) list(27.605:67.584 27.777:67.644))
dbCreateLabel(layout list(58 -1) 0.085:67.584 "CMP_ON" "centerLeft" "R0" "stick" 0.1)
mstr = dbOpenCellViewByType( pdkLib "cut_M1M3_2x1" "layout")
layInst=dbCreateInst(layout mstr "" 2.321:68.272 "R0")
mstr = dbOpenCellViewByType( pdkLib "cut_M1M3_2x1" "layout")
layInst=dbCreateInst(layout mstr "" 3.525:68.272 "R0")
mstr = dbOpenCellViewByType( pdkLib "cut_M1M3_2x1" "layout")
layInst=dbCreateInst(layout mstr "" 9.201:68.272 "R0")
mstr = dbOpenCellViewByType( pdkLib "cut_M1M3_2x1" "layout")
layInst=dbCreateInst(layout mstr "" 10.405:68.272 "R0")
mstr = dbOpenCellViewByType( pdkLib "cut_M1M3_2x1" "layout")
layInst=dbCreateInst(layout mstr "" 16.081:68.272 "R0")
mstr = dbOpenCellViewByType( pdkLib "cut_M1M3_2x1" "layout")
layInst=dbCreateInst(layout mstr "" 17.285:68.272 "R0")
mstr = dbOpenCellViewByType( pdkLib "cut_M1M3_2x1" "layout")
layInst=dbCreateInst(layout mstr "" 22.961:68.272 "R0")
mstr = dbOpenCellViewByType( pdkLib "cut_M1M3_2x1" "layout")
layInst=dbCreateInst(layout mstr "" 24.165:68.272 "R0")
mstr = dbOpenCellViewByType( pdkLib "cut_M1M3_2x1" "layout")
layInst=dbCreateInst(layout mstr "" 29.841:68.272 "R0")
fig = dbCreateRect(layout list(42 -1) list(0.429:68.277 2.321:68.327))
fig = dbCreateRect(layout list(42 -1) list(2.321:68.272 3.869:68.332))
fig = dbCreateRect(layout list(42 -1) list(2.321:68.272 9.545:68.332))
fig = dbCreateRect(layout list(42 -1) list(2.321:68.272 10.749:68.332))
fig = dbCreateRect(layout list(42 -1) list(2.321:68.272 16.425:68.332))
fig = dbCreateRect(layout list(42 -1) list(2.321:68.272 17.629:68.332))
fig = dbCreateRect(layout list(42 -1) list(2.321:68.272 23.305:68.332))
fig = dbCreateRect(layout list(42 -1) list(2.321:68.272 24.509:68.332))
fig = dbCreateRect(layout list(42 -1) list(2.321:68.272 30.185:68.332))
dbCreateLabel(layout list(58 -1) 2.321:68.272 "EN" "centerLeft" "R0" "stick" 0.1)
mstr = dbOpenCellViewByType( pdkLib "cut_M1M3_2x1" "layout")
layInst=dbCreateInst(layout mstr "" 32.679:69.734 "R0")
mstr = dbOpenCellViewByType( pdkLib "cut_M1M3_2x1" "layout")
layInst=dbCreateInst(layout mstr "" 27.605:65.52 "R0")
fig = dbCreateRect(layout list(42 -1) list(32.851:69.734 33.093:69.794))
fig = dbCreateRect(layout list(42 -1) list(27.889:65.46 33.093:65.52))
fig = dbCreateRect(layout list(42 -1) list(33.093:65.46 33.153:69.794))
fig = dbCreateRect(layout list(42 -1) list(27.777:65.52 27.949:65.58))
dbCreateLabel(layout list(58 -1) 32.679:69.734 "CMP_OP" "centerLeft" "R0" "stick" 0.1)
mstr = dbOpenCellViewByType( pdkLib "cut_M1M3_2x1" "layout")
layInst=dbCreateInst(layout mstr "" 31.661:71.11 "R0")
mstr = dbOpenCellViewByType( pdkLib "cut_M1M3_2x1" "layout")
layInst=dbCreateInst(layout mstr "" 27.619:67.584 "R0")
fig = dbCreateRect(layout list(42 -1) list(31.517:71.11 31.819:71.17))
fig = dbCreateRect(layout list(42 -1) list(27.889:67.644 31.517:67.704))
fig = dbCreateRect(layout list(42 -1) list(31.517:67.644 31.577:71.17))
fig = dbCreateRect(layout list(42 -1) list(27.777:67.584 27.949:67.644))
dbCreateLabel(layout list(58 -1) 31.647:71.11 "CMP_ON" "centerLeft" "R0" "stick" 0.1)
mstr = dbOpenCellViewByType( pdkLib "cut_M1M3_2x1" "layout")
layInst=dbCreateInst(layout mstr "" 31.045:78.248 "R0")
mstr = dbOpenCellViewByType( pdkLib "cut_M1M3_2x1" "layout")
layInst=dbCreateInst(layout mstr "" 27.605:75.152 "R0")
fig = dbCreateRect(layout list(42 -1) list(31.217:78.248 31.459:78.308))
fig = dbCreateRect(layout list(42 -1) list(27.777:75.152 31.459:75.212))
fig = dbCreateRect(layout list(42 -1) list(31.459:75.152 31.519:78.308))
dbCreateLabel(layout list(58 -1) 31.045:78.248 "CK_SAMPLE" "centerLeft" "R0" "stick" 0.1)
mstr = dbOpenCellViewByType( pdkLib "cut_M1M3_2x1" "layout")
layInst=dbCreateInst(layout mstr "" 31.059:78.936 "R0")
mstr = dbOpenCellViewByType( pdkLib "cut_M1M3_2x1" "layout")
layInst=dbCreateInst(layout mstr "" 29.253:77.99 "R0")
fig = dbCreateRect(layout list(42 -1) list(30.915:78.936 31.217:78.996))
fig = dbCreateRect(layout list(42 -1) list(29.411:77.99 30.915:78.05))
fig = dbCreateRect(layout list(42 -1) list(30.915:77.99 30.975:78.996))
dbCreateLabel(layout list(58 -1) 31.045:78.936 "CK_CMP" "centerLeft" "R0" "stick" 0.1)
mstr = dbOpenCellViewByType( pdkLib "cut_M1M2_2x1" "layout")
layInst=dbCreateInst(layout mstr "" 31.059:78.592 "R0")
mstr = dbOpenCellViewByType( pdkLib "cut_M1M2_2x1" "layout")
layInst=dbCreateInst(layout mstr "" 28.221:75.926 "R0")
fig = dbCreateRect(layout list(36 -1) list(30.915:78.592 31.217:78.652))
fig = dbCreateRect(layout list(36 -1) list(28.379:75.926 30.915:75.986))
fig = dbCreateRect(layout list(36 -1) list(30.915:75.926 30.975:78.652))
dbCreateLabel(layout list(58 -1) 31.045:78.592 "DONE" "centerLeft" "R0" "stick" 0.1)
mstr = dbOpenCellViewByType( pdkLib "cut_M1M4_2x1" "layout")
layInst=dbCreateInst(layout mstr "" 15.493:1.088 "R0")
fig = dbCreateRect(layout list(46 -1) list(15.349:1.088 15.651:1.148))
fig = dbCreateRect(layout list(46 -1) list(13.025:3.361 15.349:3.421))
mstr = dbOpenCellViewByType( pdkLib "cut_M4M5_1x2" "layout")
layInst=dbCreateInst(layout mstr "" 15.349:1.088 "R0")
mstr = dbOpenCellViewByType( pdkLib "cut_M4M5_1x2" "layout")
layInst=dbCreateInst(layout mstr "" 15.349:3.091 "R0")
fig = dbCreateRect(layout list(81 -1) list(15.349:1.088 15.409:3.421))
dbCreateLabel(layout list(58 -1) 15.479:1.088 "SARP" "centerLeft" "R0" "stick" 0.1)
mstr = dbOpenCellViewByType( pdkLib "cut_M1M4_2x1" "layout")
layInst=dbCreateInst(layout mstr "" 17.887:1.088 "R0")
fig = dbCreateRect(layout list(46 -1) list(18.059:1.088 18.301:1.148))
fig = dbCreateRect(layout list(46 -1) list(18.301:3.361 20.685:3.421))
mstr = dbOpenCellViewByType( pdkLib "cut_M4M5_1x2" "layout")
layInst=dbCreateInst(layout mstr "" 18.301:1.088 "R0")
mstr = dbOpenCellViewByType( pdkLib "cut_M4M5_1x2" "layout")
layInst=dbCreateInst(layout mstr "" 18.301:3.091 "R0")
fig = dbCreateRect(layout list(81 -1) list(18.301:1.088 18.361:3.421))
dbCreateLabel(layout list(58 -1) 17.887:1.088 "SARN" "centerLeft" "R0" "stick" 0.1)
mstr = dbOpenCellViewByType( pdkLib "cut_M1M3_2x1" "layout")
layInst=dbCreateInst(layout mstr "" 15.479:2.464 "R0")
mstr = dbOpenCellViewByType( pdkLib "cut_M1M3_2x1" "layout")
layInst=dbCreateInst(layout mstr "" 17.887:1.088 "R0")
fig = dbCreateRect(layout list(42 -1) list(15.651:2.464 15.893:2.524))
fig = dbCreateRect(layout list(42 -1) list(15.893:1.088 18.059:1.148))
fig = dbCreateRect(layout list(42 -1) list(15.893:1.088 15.953:2.524))
dbCreateLabel(layout list(58 -1) 15.479:2.464 "SARN" "centerLeft" "R0" "stick" 0.1)
mstr = dbOpenCellViewByType( pdkLib "cut_M1M4_2x1" "layout")
layInst=dbCreateInst(layout mstr "" 15.479:1.088 "R0")
mstr = dbOpenCellViewByType( pdkLib "cut_M1M4_2x1" "layout")
layInst=dbCreateInst(layout mstr "" 17.887:2.464 "R0")
fig = dbCreateRect(layout list(46 -1) list(15.651:1.088 15.893:1.148))
fig = dbCreateRect(layout list(46 -1) list(15.893:2.464 18.059:2.524))
fig = dbCreateRect(layout list(46 -1) list(15.893:1.088 15.953:2.524))
dbCreateLabel(layout list(58 -1) 15.479:1.088 "SARP" "centerLeft" "R0" "stick" 0.1)
mstr = dbOpenCellViewByType( pdkLib "cut_M1M3_2x1" "layout")
layInst=dbCreateInst(layout mstr "" 0.085:68.272 "R0")
fig = dbCreateRect(layout list(42 -1) list(0.085:68.272 2.665:68.332))
dbCreateLabel(layout list(58 -1) 0.085:68.272 "EN" "centerLeft" "R0" "stick" 0.1)
mstr = dbOpenCellViewByType( pdkLib "cut_M1M2_1x2" "layout")
layInst=dbCreateInst(layout mstr "" -1.205:-0.86 "R0")
fig = dbCreateRect(layout list(36 -1) list(-1.205:3.361 0.05:3.421))
mstr = dbOpenCellViewByType( pdkLib "cut_M1M2_1x2" "layout")
layInst=dbCreateInst(layout mstr "" -1.205:3.421 "R0")
fig = dbCreateRect(layout list(36 -1) list(-1.205:6.356 0.05:6.416))
mstr = dbOpenCellViewByType( pdkLib "cut_M1M2_1x2" "layout")
layInst=dbCreateInst(layout mstr "" -1.205:6.416 "R0")
fig = dbCreateRect(layout list(36 -1) list(-1.205:9.351 0.05:9.411))
mstr = dbOpenCellViewByType( pdkLib "cut_M1M2_1x2" "layout")
layInst=dbCreateInst(layout mstr "" -1.205:9.411 "R0")
fig = dbCreateRect(layout list(36 -1) list(-1.205:12.346 0.05:12.406))
mstr = dbOpenCellViewByType( pdkLib "cut_M1M2_1x2" "layout")
layInst=dbCreateInst(layout mstr "" -1.205:12.406 "R0")
fig = dbCreateRect(layout list(36 -1) list(-1.205:15.341 0.05:15.401))
mstr = dbOpenCellViewByType( pdkLib "cut_M1M2_1x2" "layout")
layInst=dbCreateInst(layout mstr "" -1.205:15.401 "R0")
fig = dbCreateRect(layout list(36 -1) list(-1.205:18.336 0.05:18.396))
mstr = dbOpenCellViewByType( pdkLib "cut_M1M2_1x2" "layout")
layInst=dbCreateInst(layout mstr "" -1.205:18.396 "R0")
fig = dbCreateRect(layout list(36 -1) list(-1.205:21.331 0.05:21.391))
mstr = dbOpenCellViewByType( pdkLib "cut_M1M2_1x2" "layout")
layInst=dbCreateInst(layout mstr "" -1.205:21.391 "R0")
fig = dbCreateRect(layout list(36 -1) list(-1.205:24.326 0.05:24.386))
mstr = dbOpenCellViewByType( pdkLib "cut_M1M2_1x2" "layout")
layInst=dbCreateInst(layout mstr "" -1.205:24.386 "R0")
fig = dbCreateRect(layout list(36 -1) list(-1.205:27.321 0.05:27.381))
mstr = dbOpenCellViewByType( pdkLib "cut_M1M2_1x2" "layout")
layInst=dbCreateInst(layout mstr "" -1.205:27.381 "R0")
fig = dbCreateRect(layout list(36 -1) list(-1.205:30.316 0.05:30.376))
mstr = dbOpenCellViewByType( pdkLib "cut_M1M2_1x2" "layout")
layInst=dbCreateInst(layout mstr "" -1.205:30.376 "R0")
fig = dbCreateRect(layout list(36 -1) list(-1.205:33.311 0.05:33.371))
mstr = dbOpenCellViewByType( pdkLib "cut_M1M2_1x2" "layout")
layInst=dbCreateInst(layout mstr "" -1.205:33.371 "R0")
fig = dbCreateRect(layout list(36 -1) list(-1.205:36.306 0.05:36.366))
mstr = dbOpenCellViewByType( pdkLib "cut_M1M2_1x2" "layout")
layInst=dbCreateInst(layout mstr "" -1.205:36.366 "R0")
fig = dbCreateRect(layout list(36 -1) list(-1.205:39.301 0.05:39.361))
mstr = dbOpenCellViewByType( pdkLib "cut_M1M2_1x2" "layout")
layInst=dbCreateInst(layout mstr "" -1.205:39.361 "R0")
fig = dbCreateRect(layout list(36 -1) list(-1.205:42.296 0.05:42.356))
mstr = dbOpenCellViewByType( pdkLib "cut_M1M2_1x2" "layout")
layInst=dbCreateInst(layout mstr "" -1.205:42.356 "R0")
fig = dbCreateRect(layout list(36 -1) list(-1.205:45.291 0.05:45.351))
mstr = dbOpenCellViewByType( pdkLib "cut_M1M2_1x2" "layout")
layInst=dbCreateInst(layout mstr "" -1.205:45.351 "R0")
fig = dbCreateRect(layout list(36 -1) list(-1.205:48.286 0.05:48.346))
mstr = dbOpenCellViewByType( pdkLib "cut_M1M2_1x2" "layout")
layInst=dbCreateInst(layout mstr "" -1.205:48.346 "R0")
fig = dbCreateRect(layout list(36 -1) list(-1.205:51.281 0.05:51.341))
mstr = dbOpenCellViewByType( pdkLib "cut_M1M2_1x2" "layout")
layInst=dbCreateInst(layout mstr "" -1.205:51.341 "R0")
dbCreateLabel(layout list(58 -1) -1.205:-0.86 "AVSS" "centerLeft" "R0" "stick" 0.1)
mstr = dbOpenCellViewByType( pdkLib "cut_M1M2_1x2" "layout")
layInst=dbCreateInst(layout mstr "" 34.585:-0.86 "R0")
mstr = dbOpenCellViewByType( pdkLib "cut_M1M2_1x2" "layout")
layInst=dbCreateInst(layout mstr "" 34.585:3.361 "R0")
fig = dbCreateRect(layout list(36 -1) list(33.66:3.361 34.635:3.421))
mstr = dbOpenCellViewByType( pdkLib "cut_M1M2_1x2" "layout")
layInst=dbCreateInst(layout mstr "" 34.585:6.356 "R0")
fig = dbCreateRect(layout list(36 -1) list(33.66:6.356 34.635:6.416))
mstr = dbOpenCellViewByType( pdkLib "cut_M1M2_1x2" "layout")
layInst=dbCreateInst(layout mstr "" 34.585:9.351 "R0")
fig = dbCreateRect(layout list(36 -1) list(33.66:9.351 34.635:9.411))
mstr = dbOpenCellViewByType( pdkLib "cut_M1M2_1x2" "layout")
layInst=dbCreateInst(layout mstr "" 34.585:12.346 "R0")
fig = dbCreateRect(layout list(36 -1) list(33.66:12.346 34.635:12.406))
mstr = dbOpenCellViewByType( pdkLib "cut_M1M2_1x2" "layout")
layInst=dbCreateInst(layout mstr "" 34.585:15.341 "R0")
fig = dbCreateRect(layout list(36 -1) list(33.66:15.341 34.635:15.401))
mstr = dbOpenCellViewByType( pdkLib "cut_M1M2_1x2" "layout")
layInst=dbCreateInst(layout mstr "" 34.585:18.336 "R0")
fig = dbCreateRect(layout list(36 -1) list(33.66:18.336 34.635:18.396))
mstr = dbOpenCellViewByType( pdkLib "cut_M1M2_1x2" "layout")
layInst=dbCreateInst(layout mstr "" 34.585:21.331 "R0")
fig = dbCreateRect(layout list(36 -1) list(33.66:21.331 34.635:21.391))
mstr = dbOpenCellViewByType( pdkLib "cut_M1M2_1x2" "layout")
layInst=dbCreateInst(layout mstr "" 34.585:24.326 "R0")
fig = dbCreateRect(layout list(36 -1) list(33.66:24.326 34.635:24.386))
mstr = dbOpenCellViewByType( pdkLib "cut_M1M2_1x2" "layout")
layInst=dbCreateInst(layout mstr "" 34.585:27.321 "R0")
fig = dbCreateRect(layout list(36 -1) list(33.66:27.321 34.635:27.381))
mstr = dbOpenCellViewByType( pdkLib "cut_M1M2_1x2" "layout")
layInst=dbCreateInst(layout mstr "" 34.585:30.316 "R0")
fig = dbCreateRect(layout list(36 -1) list(33.66:30.316 34.635:30.376))
mstr = dbOpenCellViewByType( pdkLib "cut_M1M2_1x2" "layout")
layInst=dbCreateInst(layout mstr "" 34.585:33.311 "R0")
fig = dbCreateRect(layout list(36 -1) list(33.66:33.311 34.635:33.371))
mstr = dbOpenCellViewByType( pdkLib "cut_M1M2_1x2" "layout")
layInst=dbCreateInst(layout mstr "" 34.585:36.306 "R0")
fig = dbCreateRect(layout list(36 -1) list(33.66:36.306 34.635:36.366))
mstr = dbOpenCellViewByType( pdkLib "cut_M1M2_1x2" "layout")
layInst=dbCreateInst(layout mstr "" 34.585:39.301 "R0")
fig = dbCreateRect(layout list(36 -1) list(33.66:39.301 34.635:39.361))
mstr = dbOpenCellViewByType( pdkLib "cut_M1M2_1x2" "layout")
layInst=dbCreateInst(layout mstr "" 34.585:42.296 "R0")
fig = dbCreateRect(layout list(36 -1) list(33.66:42.296 34.635:42.356))
mstr = dbOpenCellViewByType( pdkLib "cut_M1M2_1x2" "layout")
layInst=dbCreateInst(layout mstr "" 34.585:45.291 "R0")
fig = dbCreateRect(layout list(36 -1) list(33.66:45.291 34.635:45.351))
mstr = dbOpenCellViewByType( pdkLib "cut_M1M2_1x2" "layout")
layInst=dbCreateInst(layout mstr "" 34.585:48.286 "R0")
fig = dbCreateRect(layout list(36 -1) list(33.66:48.286 34.635:48.346))
mstr = dbOpenCellViewByType( pdkLib "cut_M1M2_1x2" "layout")
layInst=dbCreateInst(layout mstr "" 34.585:51.281 "R0")
fig = dbCreateRect(layout list(36 -1) list(33.66:51.281 34.635:51.341))
dbCreateLabel(layout list(58 -1) 20.66:3.361 "AVSS" "centerLeft" "R0" "stick" 0.1)
fig = dbCreateRect(layout list(34 -1) list(28.207:75.926 28.551:75.986))
net = dbCreateNet(layout "DONE")
dbCreateTerm( net "DONE" "inputOutput")
dbCreatePin(net fig)
dbCreateLabel(layout list(34 237) 28.207:75.926 "DONE" "centerLeft" "R0" "stick" 1.1)
fig = dbCreateRect(layout list(46 -1) list(15.479:0.233 15.809:0.283))
net = dbCreateNet(layout "SAR_IP")
dbCreateTerm( net "SAR_IP" "inputOutput")
dbCreatePin(net fig)
dbCreateLabel(layout list(46 237) 15.479:0.233 "SAR_IP" "centerLeft" "R0" "stick" 1.1)
fig = dbCreateRect(layout list(46 -1) list(17.901:0.233 18.231:0.283))
net = dbCreateNet(layout "SAR_IN")
dbCreateTerm( net "SAR_IN" "inputOutput")
dbCreatePin(net fig)
dbCreateLabel(layout list(46 237) 17.901:0.233 "SAR_IN" "centerLeft" "R0" "stick" 1.1)
fig = dbCreateRect(layout list(34 -1) list(15.479:2.464 15.823:2.524))
net = dbCreateNet(layout "SARN")
dbCreateTerm( net "SARN" "inputOutput")
dbCreatePin(net fig)
dbCreateLabel(layout list(34 237) 15.479:2.464 "SARN" "centerLeft" "R0" "stick" 1.1)
fig = dbCreateRect(layout list(34 -1) list(15.479:1.088 15.823:1.148))
net = dbCreateNet(layout "SARP")
dbCreateTerm( net "SARP" "inputOutput")
dbCreatePin(net fig)
dbCreateLabel(layout list(34 237) 15.479:1.088 "SARP" "centerLeft" "R0" "stick" 1.1)
fig = dbCreateRect(layout list(42 -1) list(0.099:64.837 0.429:64.887))
net = dbCreateNet(layout "EN")
dbCreateTerm( net "EN" "inputOutput")
dbCreatePin(net fig)
dbCreateLabel(layout list(42 237) 0.099:64.837 "EN" "centerLeft" "R0" "stick" 1.1)
fig = dbCreateRect(layout list(34 -1) list(0.085:74.464 0.429:74.524))
net = dbCreateNet(layout "CK_SAMPLE")
dbCreateTerm( net "CK_SAMPLE" "inputOutput")
dbCreatePin(net fig)
dbCreateLabel(layout list(34 237) 0.085:74.464 "CK_SAMPLE" "centerLeft" "R0" "stick" 1.1)
 dbSave(layout) )
