gdssLibName = "SAR9B"
 pdkLib = "SAR9B"
;- Create cell SAREMX1_CV
(let (layout net fig )
 layout = dbOpenCellViewByType(gdssLibName "SAREMX1_CV" "layout" "maskLayout" "w")
mstr = dbOpenCellViewByType( pdkLib "NCHDL" "layout")
layInst=dbCreateInst(layout mstr "MN0" 0.0:0.0 "R0")
mstr = dbOpenCellViewByType( pdkLib "NCHDL" "layout")
layInst=dbCreateInst(layout mstr "MN1" 0.0:0.344 "R0")
mstr = dbOpenCellViewByType( pdkLib "NCHDL" "layout")
layInst=dbCreateInst(layout mstr "MN2" 0.0:0.688 "R0")
mstr = dbOpenCellViewByType( pdkLib "NCHDL" "layout")
layInst=dbCreateInst(layout mstr "MN3" 0.0:1.032 "R0")
mstr = dbOpenCellViewByType( pdkLib "PCHDL" "layout")
layInst=dbCreateInst(layout mstr "MP0" 1.72:0.0 "R0")
mstr = dbOpenCellViewByType( pdkLib "PCHDL" "layout")
layInst=dbCreateInst(layout mstr "MP1" 1.72:0.344 "R0")
mstr = dbOpenCellViewByType( pdkLib "PCHDL" "layout")
layInst=dbCreateInst(layout mstr "MP2" 1.72:0.688 "R0")
mstr = dbOpenCellViewByType( pdkLib "PCHDL" "layout")
layInst=dbCreateInst(layout mstr "MP3" 1.72:1.032 "R0")
fig = dbCreateRect(layout list(34 -1) list(2.206:0.572 2.266:0.804))
dbCreateLabel(layout list(58 -1) 2.064:0.572 "N2" "centerLeft" "R0" "stick" 0.1)
fig = dbCreateRect(layout list(34 -1) list(2.206:0.916 2.266:1.148))
dbCreateLabel(layout list(58 -1) 2.064:0.916 "N1" "centerLeft" "R0" "stick" 0.1)
fig = dbCreateRect(layout list(34 -1) list(1.204:0.228 1.446:0.288))
fig = dbCreateRect(layout list(34 -1) list(1.204:0.572 1.446:0.632))
fig = dbCreateRect(layout list(34 -1) list(1.204:0.744 1.446:0.804))
fig = dbCreateRect(layout list(34 -1) list(1.446:0.228 1.506:0.804))
dbCreateLabel(layout list(58 -1) 1.032:0.228 "N3" "centerLeft" "R0" "stick" 0.1)
fig = dbCreateRect(layout list(34 -1) list(1.934:0.4 2.236:0.46))
fig = dbCreateRect(layout list(34 -1) list(1.204:1.26 1.934:1.32))
fig = dbCreateRect(layout list(34 -1) list(1.934:0.4 1.994:1.32))
dbCreateLabel(layout list(58 -1) 2.064:0.4 "ENO" "centerLeft" "R0" "stick" 0.1)
fig = dbCreateRect(layout list(34 -1) list(2.236:0.056 2.478:0.116))
fig = dbCreateRect(layout list(34 -1) list(2.478:1.174 2.838:1.234))
fig = dbCreateRect(layout list(34 -1) list(2.478:0.056 2.538:1.234))
dbCreateLabel(layout list(58 -1) 2.064:0.056 "AM" "centerLeft" "R0" "stick" 0.1)
fig = dbCreateRect(layout list(30 -1) list(0.774:0.501 2.666:0.531))
dbCreateLabel(layout list(58 -1) 0.774:0.501 "A" "centerLeft" "R0" "stick" 0.1)
fig = dbCreateRect(layout list(30 -1) list(0.774:0.845 2.666:0.875))
dbCreateLabel(layout list(58 -1) 0.774:0.845 "B" "centerLeft" "R0" "stick" 0.1)
fig = dbCreateRect(layout list(30 -1) list(0.774:1.189 2.666:1.219))
dbCreateLabel(layout list(58 -1) 0.774:1.189 "AM" "centerLeft" "R0" "stick" 0.1)
fig = dbCreateRect(layout list(34 -1) list(1.032:0.056 2.408:0.116))
dbCreateLabel(layout list(58 -1) 1.032:0.056 "AM" "centerLeft" "R0" "stick" 0.1)
fig = dbCreateRect(layout list(34 -1) list(0.43:0.83 0.774:0.89))
net = dbCreateNet(layout "A")
dbCreateTerm( net "A" "inputOutput")
dbCreatePin(net fig)
dbCreateLabel(layout list(34 237) 0.43:0.83 "A" "centerLeft" "R0" "stick" 0.1)
fig = dbCreateRect(layout list(34 -1) list(0.43:0.486 0.774:0.546))
net = dbCreateNet(layout "B")
dbCreateTerm( net "B" "inputOutput")
dbCreatePin(net fig)
dbCreateLabel(layout list(34 237) 0.43:0.486 "B" "centerLeft" "R0" "stick" 0.1)
fig = dbCreateRect(layout list(34 -1) list(2.666:0.142 3.01:0.202))
net = dbCreateNet(layout "RST_N")
dbCreateTerm( net "RST_N" "inputOutput")
dbCreatePin(net fig)
dbCreateLabel(layout list(34 237) 2.666:0.142 "RST_N" "centerLeft" "R0" "stick" 0.1)
fig = dbCreateRect(layout list(34 -1) list(0.43:0.142 0.774:0.202))
net = dbCreateNet(layout "EN")
dbCreateTerm( net "EN" "inputOutput")
dbCreatePin(net fig)
dbCreateLabel(layout list(34 237) 0.43:0.142 "EN" "centerLeft" "R0" "stick" 0.1)
fig = dbCreateRect(layout list(34 -1) list(2.064:0.4 2.408:0.46))
net = dbCreateNet(layout "ENO")
dbCreateTerm( net "ENO" "inputOutput")
dbCreatePin(net fig)
dbCreateLabel(layout list(34 237) 2.064:0.4 "ENO" "centerLeft" "R0" "stick" 0.1)
fig = dbCreateRect(layout list(46 -1) list(2.064:0.0 2.394:1.376))
net = dbCreateNet(layout "AVDD")
dbCreateTerm( net "AVDD" "inputOutput")
dbCreatePin(net fig)
dbCreateLabel(layout list(46 237) 2.064:0.0 "AVDD" "centerLeft" "R0" "stick" 0.1)
fig = dbCreateRect(layout list(46 -1) list(1.032:0.0 1.362:1.376))
net = dbCreateNet(layout "AVSS")
dbCreateTerm( net "AVSS" "inputOutput")
dbCreatePin(net fig)
dbCreateLabel(layout list(46 237) 1.032:0.0 "AVSS" "centerLeft" "R0" "stick" 0.1)
mstr = dbOpenCellViewByType( pdkLib "cut_M1M4_2x1" "layout")
layInst=dbCreateInst(layout mstr "" 2.064:0.228 "R0")
mstr = dbOpenCellViewByType( pdkLib "cut_M1M4_2x1" "layout")
layInst=dbCreateInst(layout mstr "" 2.064:1.26 "R0")
fig = dbCreateRect(layout list(46 -1) list(2.064:0.0 2.394:1.376))
mstr = dbOpenCellViewByType( pdkLib "cut_M1M4_2x1" "layout")
layInst=dbCreateInst(layout mstr "" 1.032:0.4 "R0")
mstr = dbOpenCellViewByType( pdkLib "cut_M1M4_2x1" "layout")
layInst=dbCreateInst(layout mstr "" 1.032:0.916 "R0")
mstr = dbOpenCellViewByType( pdkLib "cut_M1M4_2x1" "layout")
layInst=dbCreateInst(layout mstr "" 1.032:1.088 "R0")
fig = dbCreateRect(layout list(46 -1) list(1.032:0.0 1.362:1.376))
 dbSave(layout) )
