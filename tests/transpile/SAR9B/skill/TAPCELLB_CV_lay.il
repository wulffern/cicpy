gdssLibName = "SAR9B"
 pdkLib = "SAR9B"
;- Create cell TAPCELLB_CV
(let (layout net fig )
 layout = dbOpenCellViewByType(gdssLibName "TAPCELLB_CV" "layout" "maskLayout" "w")
mstr = dbOpenCellViewByType( pdkLib "NCHDL" "layout")
layInst=dbCreateInst(layout mstr "MN1" 0.0:0.0 "R0")
mstr = dbOpenCellViewByType( pdkLib "PCHDL" "layout")
layInst=dbCreateInst(layout mstr "MP1" 1.72:0.0 "R0")
fig = dbCreateRect(layout list(34 -1) list(-0.172:0.142 0.774:0.202))
dbCreateLabel(layout list(58 -1) -0.172:0.129 "TAP" "centerLeft" "R0" "stick" 0.1)
fig = dbCreateRect(layout list(34 -1) list(0.602:0.142 0.844:0.202))
fig = dbCreateRect(layout list(34 -1) list(0.844:0.056 1.204:0.116))
fig = dbCreateRect(layout list(34 -1) list(0.844:0.056 0.904:0.202))
dbCreateLabel(layout list(58 -1) 0.43:0.142 "TAP" "centerLeft" "R0" "stick" 0.1)
fig = dbCreateRect(layout list(34 -1) list(0.602:0.142 0.844:0.202))
fig = dbCreateRect(layout list(34 -1) list(0.844:0.228 1.204:0.288))
fig = dbCreateRect(layout list(34 -1) list(0.844:0.142 0.904:0.288))
dbCreateLabel(layout list(58 -1) 0.43:0.142 "TAP" "centerLeft" "R0" "stick" 0.1)
fig = dbCreateRect(layout list(34 -1) list(2.236:0.056 2.478:0.116))
fig = dbCreateRect(layout list(34 -1) list(2.478:0.142 2.838:0.202))
fig = dbCreateRect(layout list(34 -1) list(2.478:0.056 2.538:0.202))
dbCreateLabel(layout list(58 -1) 2.064:0.056 "TAP" "centerLeft" "R0" "stick" 0.1)
fig = dbCreateRect(layout list(34 -1) list(2.236:0.228 2.478:0.288))
fig = dbCreateRect(layout list(34 -1) list(2.478:0.142 2.838:0.202))
fig = dbCreateRect(layout list(34 -1) list(2.478:0.142 2.538:0.288))
dbCreateLabel(layout list(58 -1) 2.064:0.228 "TAP" "centerLeft" "R0" "stick" 0.1)
fig = dbCreateRect(layout list(34 -1) list(2.838:0.142 3.08:0.202))
fig = dbCreateRect(layout list(34 -1) list(3.08:0.129 3.44:0.189))
fig = dbCreateRect(layout list(34 -1) list(3.08:0.129 3.14:0.202))
dbCreateLabel(layout list(58 -1) 2.666:0.142 "TAP" "centerLeft" "R0" "stick" 0.1)
fig = dbCreateRect(layout list(46 -1) list(1.032:0.0 1.362:0.344))
net = dbCreateNet(layout "AVSS")
dbCreateTerm( net "AVSS" "inputOutput")
dbCreatePin(net fig)
dbCreateLabel(layout list(46 237) 1.032:0.0 "AVSS" "centerLeft" "R0" "stick" 0.1)
fig = dbCreateRect(layout list(46 -1) list(2.064:0.0 2.394:0.344))
net = dbCreateNet(layout "AVDD")
dbCreateTerm( net "AVDD" "inputOutput")
dbCreatePin(net fig)
dbCreateLabel(layout list(46 237) 2.064:0.0 "AVDD" "centerLeft" "R0" "stick" 0.1)
mstr = dbOpenCellViewByType( pdkLib "cut_M1M4_2x1" "layout")
layInst=dbCreateInst(layout mstr "" 2.064:0.228 "R0")
mstr = dbOpenCellViewByType( pdkLib "cut_M1M4_2x1" "layout")
layInst=dbCreateInst(layout mstr "" 2.064:0.056 "R0")
fig = dbCreateRect(layout list(46 -1) list(2.064:0.0 2.394:0.344))
mstr = dbOpenCellViewByType( pdkLib "cut_M1M4_2x1" "layout")
layInst=dbCreateInst(layout mstr "" 1.032:0.228 "R0")
mstr = dbOpenCellViewByType( pdkLib "cut_M1M4_2x1" "layout")
layInst=dbCreateInst(layout mstr "" 1.032:0.056 "R0")
fig = dbCreateRect(layout list(46 -1) list(1.032:0.0 1.362:0.344))
 dbSave(layout) )
