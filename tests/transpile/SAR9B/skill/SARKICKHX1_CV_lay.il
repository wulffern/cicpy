gdssLibName = "SAR9B"
 pdkLib = "SAR9B"
;- Create cell SARKICKHX1_CV
(let (layout net fig )
 layout = dbOpenCellViewByType(gdssLibName "SARKICKHX1_CV" "layout" "maskLayout" "w")
mstr = dbOpenCellViewByType( pdkLib "NCHDL" "layout")
layInst=dbCreateInst(layout mstr "MN0" 0.0:0.0 "R0")
mstr = dbOpenCellViewByType( pdkLib "NCHDL" "layout")
layInst=dbCreateInst(layout mstr "MN1" 0.0:0.344 "R0")
mstr = dbOpenCellViewByType( pdkLib "NCHDL" "layout")
layInst=dbCreateInst(layout mstr "MN2" 0.0:0.688 "R0")
mstr = dbOpenCellViewByType( pdkLib "NCHDL" "layout")
layInst=dbCreateInst(layout mstr "MN3" 0.0:1.032 "R0")
mstr = dbOpenCellViewByType( pdkLib "NCHDL" "layout")
layInst=dbCreateInst(layout mstr "MN4" 0.0:1.376 "R0")
mstr = dbOpenCellViewByType( pdkLib "NCHDL" "layout")
layInst=dbCreateInst(layout mstr "MN5" 0.0:1.72 "R0")
mstr = dbOpenCellViewByType( pdkLib "NCHDL" "layout")
layInst=dbCreateInst(layout mstr "MN6" 0.0:2.064 "R0")
mstr = dbOpenCellViewByType( pdkLib "PCHDL" "layout")
layInst=dbCreateInst(layout mstr "MP0" 1.72:0.0 "R0")
mstr = dbOpenCellViewByType( pdkLib "PCHDL" "layout")
layInst=dbCreateInst(layout mstr "MP1_DMY" 1.72:0.344 "R0")
mstr = dbOpenCellViewByType( pdkLib "PCHDL" "layout")
layInst=dbCreateInst(layout mstr "MP2_DMY" 1.72:0.688 "R0")
mstr = dbOpenCellViewByType( pdkLib "PCHDL" "layout")
layInst=dbCreateInst(layout mstr "MP3_DMY" 1.72:1.032 "R0")
mstr = dbOpenCellViewByType( pdkLib "PCHDL" "layout")
layInst=dbCreateInst(layout mstr "MP4_DMY" 1.72:1.376 "R0")
mstr = dbOpenCellViewByType( pdkLib "PCHDL" "layout")
layInst=dbCreateInst(layout mstr "MP5_DMY" 1.72:1.72 "R0")
mstr = dbOpenCellViewByType( pdkLib "PCHDL" "layout")
layInst=dbCreateInst(layout mstr "MP6" 1.72:2.064 "R0")
fig = dbCreateRect(layout list(34 -1) list(1.174:0.228 1.234:2.18))
dbCreateLabel(layout list(58 -1) 1.032:0.228 "N1" "centerLeft" "R0" "stick" 0.1)
fig = dbCreateRect(layout list(34 -1) list(1.204:0.228 1.446:0.288))
fig = dbCreateRect(layout list(34 -1) list(1.446:0.056 2.236:0.116))
fig = dbCreateRect(layout list(34 -1) list(1.446:0.056 1.506:0.288))
dbCreateLabel(layout list(58 -1) 1.032:0.228 "N1" "centerLeft" "R0" "stick" 0.1)
fig = dbCreateRect(layout list(34 -1) list(0.572:0.486 0.632:1.922))
dbCreateLabel(layout list(58 -1) 0.43:0.486 "CI" "centerLeft" "R0" "stick" 0.1)
fig = dbCreateRect(layout list(30 -1) list(0.774:0.157 2.666:0.187))
dbCreateLabel(layout list(58 -1) 0.774:0.157 "CKN" "centerLeft" "R0" "stick" 0.1)
fig = dbCreateRect(layout list(34 -1) list(2.808:0.486 2.868:2.266))
dbCreateLabel(layout list(58 -1) 2.666:0.486 "NC" "centerLeft" "R0" "stick" 0.1)
fig = dbCreateRect(layout list(34 -1) list(2.206:0.4 2.266:2.352))
dbCreateLabel(layout list(58 -1) 2.064:0.4 "NC" "centerLeft" "R0" "stick" 0.1)
fig = dbCreateRect(layout list(34 -1) list(1.032:2.292 2.408:2.352))
dbCreateLabel(layout list(58 -1) 1.032:2.292 "NC" "centerLeft" "R0" "stick" 0.1)
fig = dbCreateRect(layout list(34 -1) list(2.236:2.292 2.478:2.352))
fig = dbCreateRect(layout list(34 -1) list(2.478:2.206 2.838:2.266))
fig = dbCreateRect(layout list(34 -1) list(2.478:2.206 2.538:2.352))
dbCreateLabel(layout list(58 -1) 2.064:2.292 "NC" "centerLeft" "R0" "stick" 0.1)
fig = dbCreateRect(layout list(34 -1) list(0.43:2.206 0.774:2.266))
net = dbCreateNet(layout "CK")
dbCreateTerm( net "CK" "inputOutput")
dbCreatePin(net fig)
dbCreateLabel(layout list(34 237) 0.43:2.206 "CK" "centerLeft" "R0" "stick" 0.1)
fig = dbCreateRect(layout list(34 -1) list(0.43:0.142 0.774:0.202))
net = dbCreateNet(layout "CKN")
dbCreateTerm( net "CKN" "inputOutput")
dbCreatePin(net fig)
dbCreateLabel(layout list(34 237) 0.43:0.142 "CKN" "centerLeft" "R0" "stick" 0.1)
fig = dbCreateRect(layout list(34 -1) list(0.43:0.486 0.774:0.546))
net = dbCreateNet(layout "CI")
dbCreateTerm( net "CI" "inputOutput")
dbCreatePin(net fig)
dbCreateLabel(layout list(34 237) 0.43:0.486 "CI" "centerLeft" "R0" "stick" 0.1)
fig = dbCreateRect(layout list(46 -1) list(2.064:0.0 2.394:2.408))
net = dbCreateNet(layout "AVDD")
dbCreateTerm( net "AVDD" "inputOutput")
dbCreatePin(net fig)
dbCreateLabel(layout list(46 237) 2.064:0.0 "AVDD" "centerLeft" "R0" "stick" 0.1)
fig = dbCreateRect(layout list(46 -1) list(1.032:0.0 1.362:2.408))
net = dbCreateNet(layout "AVSS")
dbCreateTerm( net "AVSS" "inputOutput")
dbCreatePin(net fig)
dbCreateLabel(layout list(46 237) 1.032:0.0 "AVSS" "centerLeft" "R0" "stick" 0.1)
mstr = dbOpenCellViewByType( pdkLib "cut_M1M4_2x1" "layout")
layInst=dbCreateInst(layout mstr "" 2.064:0.228 "R0")
mstr = dbOpenCellViewByType( pdkLib "cut_M1M4_2x1" "layout")
layInst=dbCreateInst(layout mstr "" 2.064:2.292 "R0")
mstr = dbOpenCellViewByType( pdkLib "cut_M1M4_2x1" "layout")
layInst=dbCreateInst(layout mstr "" 2.064:2.12 "R0")
fig = dbCreateRect(layout list(46 -1) list(2.064:0.0 2.394:2.408))
mstr = dbOpenCellViewByType( pdkLib "cut_M1M4_2x1" "layout")
layInst=dbCreateInst(layout mstr "" 1.032:0.056 "R0")
fig = dbCreateRect(layout list(46 -1) list(1.032:0.0 1.362:2.408))
 dbSave(layout) )
