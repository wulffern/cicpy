gdssLibName = "SAR9B"
 pdkLib = "SAR9B"
;- Create cell CDAC9_CV
(let (layout net fig )
 layout = dbOpenCellViewByType(gdssLibName "CDAC9_CV" "layout" "maskLayout" "w")
mstr = dbOpenCellViewByType( pdkLib "CAP32C_CV" "layout")
layInst=dbCreateInst(layout mstr "XC1" 3.0:0.0 "R0")
mstr = dbOpenCellViewByType( pdkLib "CAP32C_CV" "layout")
layInst=dbCreateInst(layout mstr "XC256a<7>" 3.0:2.995 "R0")
mstr = dbOpenCellViewByType( pdkLib "CAP32C_CV" "layout")
layInst=dbCreateInst(layout mstr "XC128b<3>" 3.0:5.99 "R0")
mstr = dbOpenCellViewByType( pdkLib "CAP32C_CV" "layout")
layInst=dbCreateInst(layout mstr "XC64a<0>" 3.0:8.985 "R0")
mstr = dbOpenCellViewByType( pdkLib "CAP32C_CV" "layout")
layInst=dbCreateInst(layout mstr "XC32a<0>" 3.0:11.98 "R0")
mstr = dbOpenCellViewByType( pdkLib "CAP32C_CV" "layout")
layInst=dbCreateInst(layout mstr "XCS" 3.0:14.975 "R0")
mstr = dbOpenCellViewByType( pdkLib "CAP32C_CV" "layout")
layInst=dbCreateInst(layout mstr "XC128a<1>" 3.0:17.97 "R0")
mstr = dbOpenCellViewByType( pdkLib "CAP32C_CV" "layout")
layInst=dbCreateInst(layout mstr "XC256b<5>" 3.0:20.965 "R0")
mstr = dbOpenCellViewByType( pdkLib "CAP32C_CV" "layout")
layInst=dbCreateInst(layout mstr "XC256a<5>" 3.0:23.96 "R0")
mstr = dbOpenCellViewByType( pdkLib "CAP32C_CV" "layout")
layInst=dbCreateInst(layout mstr "XC256b<2>" 3.0:26.955 "R0")
mstr = dbOpenCellViewByType( pdkLib "CAP32C_CV" "layout")
layInst=dbCreateInst(layout mstr "XC256a<2>" 3.0:29.95 "R0")
mstr = dbOpenCellViewByType( pdkLib "CAP32C_CV" "layout")
layInst=dbCreateInst(layout mstr "XC128b<2>" 3.0:32.945 "R0")
mstr = dbOpenCellViewByType( pdkLib "CAP32C_CV" "layout")
layInst=dbCreateInst(layout mstr "X16ab" 3.0:35.94 "R0")
mstr = dbOpenCellViewByType( pdkLib "CAP32C_CV" "layout")
layInst=dbCreateInst(layout mstr "XC64b<1>" 3.0:38.935 "R0")
mstr = dbOpenCellViewByType( pdkLib "CAP32C_CV" "layout")
layInst=dbCreateInst(layout mstr "XC128a<0>" 3.0:41.93 "R0")
mstr = dbOpenCellViewByType( pdkLib "CAP32C_CV" "layout")
layInst=dbCreateInst(layout mstr "XC256b<0>" 3.0:44.925 "R0")
mstr = dbOpenCellViewByType( pdkLib "CAP32C_CV" "layout")
layInst=dbCreateInst(layout mstr "XC0" 3.0:47.92 "R0")
fig = dbCreateRect(layout list(36 -1) list(2.72:3.195 2.78:50.915))
net = dbCreateNet(layout "CP<13>")
dbCreateTerm( net "CP<13>" "inputOutput")
dbCreatePin(net fig)
dbCreateLabel(layout list(36 237) 2.72:3.195 "CP<13>" "centerLeft" "R0" "stick" 0.1)
fig = dbCreateRect(layout list(36 -1) list(2.72:3.195 2.78:50.915))
mstr = dbOpenCellViewByType( pdkLib "cut_M1M3_2x1" "layout")
layInst=dbCreateInst(layout mstr "" 3.0:3.335 "R0")
mstr = dbOpenCellViewByType( pdkLib "cut_M2M3_1x2" "layout")
layInst=dbCreateInst(layout mstr "" 2.725:3.195 "R0")
fig = dbCreateRect(layout list(42 -1) list(2.78:3.335 3.0:3.385))
dbCreateLabel(layout list(58 -1) 3.0:3.335 "CP<13>" "centerLeft" "R0" "stick" 0.1)
mstr = dbOpenCellViewByType( pdkLib "cut_M1M3_2x1" "layout")
layInst=dbCreateInst(layout mstr "" 3.0:5.66 "R0")
mstr = dbOpenCellViewByType( pdkLib "cut_M2M3_1x2" "layout")
layInst=dbCreateInst(layout mstr "" 2.725:5.52 "R0")
fig = dbCreateRect(layout list(42 -1) list(2.78:5.66 3.0:5.71))
dbCreateLabel(layout list(58 -1) 3.0:5.66 "CP<13>" "centerLeft" "R0" "stick" 0.1)
mstr = dbOpenCellViewByType( pdkLib "cut_M1M3_2x1" "layout")
layInst=dbCreateInst(layout mstr "" 3.0:4.265 "R0")
mstr = dbOpenCellViewByType( pdkLib "cut_M2M3_1x2" "layout")
layInst=dbCreateInst(layout mstr "" 2.725:4.125 "R0")
fig = dbCreateRect(layout list(42 -1) list(2.78:4.265 3.0:4.315))
dbCreateLabel(layout list(58 -1) 3.0:4.265 "CP<13>" "centerLeft" "R0" "stick" 0.1)
mstr = dbOpenCellViewByType( pdkLib "cut_M1M3_2x1" "layout")
layInst=dbCreateInst(layout mstr "" 3.0:5.195 "R0")
mstr = dbOpenCellViewByType( pdkLib "cut_M2M3_1x2" "layout")
layInst=dbCreateInst(layout mstr "" 2.725:5.055 "R0")
fig = dbCreateRect(layout list(42 -1) list(2.78:5.195 3.0:5.245))
dbCreateLabel(layout list(58 -1) 3.0:5.195 "CP<13>" "centerLeft" "R0" "stick" 0.1)
mstr = dbOpenCellViewByType( pdkLib "cut_M1M3_2x1" "layout")
layInst=dbCreateInst(layout mstr "" 3.0:4.73 "R0")
mstr = dbOpenCellViewByType( pdkLib "cut_M2M3_1x2" "layout")
layInst=dbCreateInst(layout mstr "" 2.725:4.59 "R0")
fig = dbCreateRect(layout list(42 -1) list(2.78:4.73 3.0:4.78))
dbCreateLabel(layout list(58 -1) 3.0:4.73 "CP<13>" "centerLeft" "R0" "stick" 0.1)
mstr = dbOpenCellViewByType( pdkLib "cut_M1M3_2x1" "layout")
layInst=dbCreateInst(layout mstr "" 3.0:3.8 "R0")
mstr = dbOpenCellViewByType( pdkLib "cut_M2M3_1x2" "layout")
layInst=dbCreateInst(layout mstr "" 2.725:3.66 "R0")
fig = dbCreateRect(layout list(42 -1) list(2.78:3.8 3.0:3.85))
dbCreateLabel(layout list(58 -1) 3.0:3.8 "CP<13>" "centerLeft" "R0" "stick" 0.1)
mstr = dbOpenCellViewByType( pdkLib "cut_M1M3_2x1" "layout")
layInst=dbCreateInst(layout mstr "" 3.0:24.3 "R0")
mstr = dbOpenCellViewByType( pdkLib "cut_M2M3_1x2" "layout")
layInst=dbCreateInst(layout mstr "" 2.725:24.16 "R0")
fig = dbCreateRect(layout list(42 -1) list(2.78:24.3 3.0:24.35))
dbCreateLabel(layout list(58 -1) 3.0:24.3 "CP<13>" "centerLeft" "R0" "stick" 0.1)
mstr = dbOpenCellViewByType( pdkLib "cut_M1M3_2x1" "layout")
layInst=dbCreateInst(layout mstr "" 3.0:26.625 "R0")
mstr = dbOpenCellViewByType( pdkLib "cut_M2M3_1x2" "layout")
layInst=dbCreateInst(layout mstr "" 2.725:26.485 "R0")
fig = dbCreateRect(layout list(42 -1) list(2.78:26.625 3.0:26.675))
dbCreateLabel(layout list(58 -1) 3.0:26.625 "CP<13>" "centerLeft" "R0" "stick" 0.1)
mstr = dbOpenCellViewByType( pdkLib "cut_M1M3_2x1" "layout")
layInst=dbCreateInst(layout mstr "" 3.0:25.23 "R0")
mstr = dbOpenCellViewByType( pdkLib "cut_M2M3_1x2" "layout")
layInst=dbCreateInst(layout mstr "" 2.725:25.09 "R0")
fig = dbCreateRect(layout list(42 -1) list(2.78:25.23 3.0:25.28))
dbCreateLabel(layout list(58 -1) 3.0:25.23 "CP<13>" "centerLeft" "R0" "stick" 0.1)
mstr = dbOpenCellViewByType( pdkLib "cut_M1M3_2x1" "layout")
layInst=dbCreateInst(layout mstr "" 3.0:26.16 "R0")
mstr = dbOpenCellViewByType( pdkLib "cut_M2M3_1x2" "layout")
layInst=dbCreateInst(layout mstr "" 2.725:26.02 "R0")
fig = dbCreateRect(layout list(42 -1) list(2.78:26.16 3.0:26.21))
dbCreateLabel(layout list(58 -1) 3.0:26.16 "CP<13>" "centerLeft" "R0" "stick" 0.1)
mstr = dbOpenCellViewByType( pdkLib "cut_M1M3_2x1" "layout")
layInst=dbCreateInst(layout mstr "" 3.0:25.695 "R0")
mstr = dbOpenCellViewByType( pdkLib "cut_M2M3_1x2" "layout")
layInst=dbCreateInst(layout mstr "" 2.725:25.555 "R0")
fig = dbCreateRect(layout list(42 -1) list(2.78:25.695 3.0:25.745))
dbCreateLabel(layout list(58 -1) 3.0:25.695 "CP<13>" "centerLeft" "R0" "stick" 0.1)
mstr = dbOpenCellViewByType( pdkLib "cut_M1M3_2x1" "layout")
layInst=dbCreateInst(layout mstr "" 3.0:24.765 "R0")
mstr = dbOpenCellViewByType( pdkLib "cut_M2M3_1x2" "layout")
layInst=dbCreateInst(layout mstr "" 2.725:24.625 "R0")
fig = dbCreateRect(layout list(42 -1) list(2.78:24.765 3.0:24.815))
dbCreateLabel(layout list(58 -1) 3.0:24.765 "CP<13>" "centerLeft" "R0" "stick" 0.1)
mstr = dbOpenCellViewByType( pdkLib "cut_M1M3_2x1" "layout")
layInst=dbCreateInst(layout mstr "" 3.0:30.29 "R0")
mstr = dbOpenCellViewByType( pdkLib "cut_M2M3_1x2" "layout")
layInst=dbCreateInst(layout mstr "" 2.725:30.15 "R0")
fig = dbCreateRect(layout list(42 -1) list(2.78:30.29 3.0:30.34))
dbCreateLabel(layout list(58 -1) 3.0:30.29 "CP<13>" "centerLeft" "R0" "stick" 0.1)
mstr = dbOpenCellViewByType( pdkLib "cut_M1M3_2x1" "layout")
layInst=dbCreateInst(layout mstr "" 3.0:32.615 "R0")
mstr = dbOpenCellViewByType( pdkLib "cut_M2M3_1x2" "layout")
layInst=dbCreateInst(layout mstr "" 2.725:32.475 "R0")
fig = dbCreateRect(layout list(42 -1) list(2.78:32.615 3.0:32.665))
dbCreateLabel(layout list(58 -1) 3.0:32.615 "CP<13>" "centerLeft" "R0" "stick" 0.1)
mstr = dbOpenCellViewByType( pdkLib "cut_M1M3_2x1" "layout")
layInst=dbCreateInst(layout mstr "" 3.0:31.22 "R0")
mstr = dbOpenCellViewByType( pdkLib "cut_M2M3_1x2" "layout")
layInst=dbCreateInst(layout mstr "" 2.725:31.08 "R0")
fig = dbCreateRect(layout list(42 -1) list(2.78:31.22 3.0:31.27))
dbCreateLabel(layout list(58 -1) 3.0:31.22 "CP<13>" "centerLeft" "R0" "stick" 0.1)
mstr = dbOpenCellViewByType( pdkLib "cut_M1M3_2x1" "layout")
layInst=dbCreateInst(layout mstr "" 3.0:32.15 "R0")
mstr = dbOpenCellViewByType( pdkLib "cut_M2M3_1x2" "layout")
layInst=dbCreateInst(layout mstr "" 2.725:32.01 "R0")
fig = dbCreateRect(layout list(42 -1) list(2.78:32.15 3.0:32.2))
dbCreateLabel(layout list(58 -1) 3.0:32.15 "CP<13>" "centerLeft" "R0" "stick" 0.1)
mstr = dbOpenCellViewByType( pdkLib "cut_M1M3_2x1" "layout")
layInst=dbCreateInst(layout mstr "" 3.0:31.685 "R0")
mstr = dbOpenCellViewByType( pdkLib "cut_M2M3_1x2" "layout")
layInst=dbCreateInst(layout mstr "" 2.725:31.545 "R0")
fig = dbCreateRect(layout list(42 -1) list(2.78:31.685 3.0:31.735))
dbCreateLabel(layout list(58 -1) 3.0:31.685 "CP<13>" "centerLeft" "R0" "stick" 0.1)
mstr = dbOpenCellViewByType( pdkLib "cut_M1M3_2x1" "layout")
layInst=dbCreateInst(layout mstr "" 3.0:30.755 "R0")
mstr = dbOpenCellViewByType( pdkLib "cut_M2M3_1x2" "layout")
layInst=dbCreateInst(layout mstr "" 2.725:30.615 "R0")
fig = dbCreateRect(layout list(42 -1) list(2.78:30.755 3.0:30.805))
dbCreateLabel(layout list(58 -1) 3.0:30.755 "CP<13>" "centerLeft" "R0" "stick" 0.1)
mstr = dbOpenCellViewByType( pdkLib "cut_M1M3_2x1" "layout")
layInst=dbCreateInst(layout mstr "" 3.0:48.26 "R0")
mstr = dbOpenCellViewByType( pdkLib "cut_M2M3_1x2" "layout")
layInst=dbCreateInst(layout mstr "" 2.725:48.12 "R0")
fig = dbCreateRect(layout list(42 -1) list(2.78:48.26 3.0:48.31))
dbCreateLabel(layout list(58 -1) 3.0:48.26 "CP<13>" "centerLeft" "R0" "stick" 0.1)
mstr = dbOpenCellViewByType( pdkLib "cut_M1M3_2x1" "layout")
layInst=dbCreateInst(layout mstr "" 3.0:50.585 "R0")
mstr = dbOpenCellViewByType( pdkLib "cut_M2M3_1x2" "layout")
layInst=dbCreateInst(layout mstr "" 2.725:50.445 "R0")
fig = dbCreateRect(layout list(42 -1) list(2.78:50.585 3.0:50.635))
dbCreateLabel(layout list(58 -1) 3.0:50.585 "CP<13>" "centerLeft" "R0" "stick" 0.1)
mstr = dbOpenCellViewByType( pdkLib "cut_M1M3_2x1" "layout")
layInst=dbCreateInst(layout mstr "" 3.0:49.19 "R0")
mstr = dbOpenCellViewByType( pdkLib "cut_M2M3_1x2" "layout")
layInst=dbCreateInst(layout mstr "" 2.725:49.05 "R0")
fig = dbCreateRect(layout list(42 -1) list(2.78:49.19 3.0:49.24))
dbCreateLabel(layout list(58 -1) 3.0:49.19 "CP<13>" "centerLeft" "R0" "stick" 0.1)
mstr = dbOpenCellViewByType( pdkLib "cut_M1M3_2x1" "layout")
layInst=dbCreateInst(layout mstr "" 3.0:50.12 "R0")
mstr = dbOpenCellViewByType( pdkLib "cut_M2M3_1x2" "layout")
layInst=dbCreateInst(layout mstr "" 2.725:49.98 "R0")
fig = dbCreateRect(layout list(42 -1) list(2.78:50.12 3.0:50.17))
dbCreateLabel(layout list(58 -1) 3.0:50.12 "CP<13>" "centerLeft" "R0" "stick" 0.1)
mstr = dbOpenCellViewByType( pdkLib "cut_M1M3_2x1" "layout")
layInst=dbCreateInst(layout mstr "" 3.0:49.655 "R0")
mstr = dbOpenCellViewByType( pdkLib "cut_M2M3_1x2" "layout")
layInst=dbCreateInst(layout mstr "" 2.725:49.515 "R0")
fig = dbCreateRect(layout list(42 -1) list(2.78:49.655 3.0:49.705))
dbCreateLabel(layout list(58 -1) 3.0:49.655 "CP<13>" "centerLeft" "R0" "stick" 0.1)
mstr = dbOpenCellViewByType( pdkLib "cut_M1M3_2x1" "layout")
layInst=dbCreateInst(layout mstr "" 3.0:48.725 "R0")
mstr = dbOpenCellViewByType( pdkLib "cut_M2M3_1x2" "layout")
layInst=dbCreateInst(layout mstr "" 2.725:48.585 "R0")
fig = dbCreateRect(layout list(42 -1) list(2.78:48.725 3.0:48.775))
dbCreateLabel(layout list(58 -1) 3.0:48.725 "CP<13>" "centerLeft" "R0" "stick" 0.1)
fig = dbCreateRect(layout list(36 -1) list(2.52:0.2 2.58:50.915))
net = dbCreateNet(layout "CP<12>")
dbCreateTerm( net "CP<12>" "inputOutput")
dbCreatePin(net fig)
dbCreateLabel(layout list(36 237) 2.52:0.2 "CP<12>" "centerLeft" "R0" "stick" 0.1)
fig = dbCreateRect(layout list(36 -1) list(2.52:0.2 2.58:50.915))
mstr = dbOpenCellViewByType( pdkLib "cut_M1M3_2x1" "layout")
layInst=dbCreateInst(layout mstr "" 3.0:0.34 "R0")
mstr = dbOpenCellViewByType( pdkLib "cut_M2M3_1x2" "layout")
layInst=dbCreateInst(layout mstr "" 2.525:0.2 "R0")
fig = dbCreateRect(layout list(42 -1) list(2.58:0.34 3.0:0.39))
dbCreateLabel(layout list(58 -1) 3.0:0.34 "CP<12>" "centerLeft" "R0" "stick" 0.1)
mstr = dbOpenCellViewByType( pdkLib "cut_M1M3_2x1" "layout")
layInst=dbCreateInst(layout mstr "" 3.0:2.665 "R0")
mstr = dbOpenCellViewByType( pdkLib "cut_M2M3_1x2" "layout")
layInst=dbCreateInst(layout mstr "" 2.525:2.525 "R0")
fig = dbCreateRect(layout list(42 -1) list(2.58:2.665 3.0:2.715))
dbCreateLabel(layout list(58 -1) 3.0:2.665 "CP<12>" "centerLeft" "R0" "stick" 0.1)
mstr = dbOpenCellViewByType( pdkLib "cut_M1M3_2x1" "layout")
layInst=dbCreateInst(layout mstr "" 3.0:1.27 "R0")
mstr = dbOpenCellViewByType( pdkLib "cut_M2M3_1x2" "layout")
layInst=dbCreateInst(layout mstr "" 2.525:1.13 "R0")
fig = dbCreateRect(layout list(42 -1) list(2.58:1.27 3.0:1.32))
dbCreateLabel(layout list(58 -1) 3.0:1.27 "CP<12>" "centerLeft" "R0" "stick" 0.1)
mstr = dbOpenCellViewByType( pdkLib "cut_M1M3_2x1" "layout")
layInst=dbCreateInst(layout mstr "" 3.0:2.2 "R0")
mstr = dbOpenCellViewByType( pdkLib "cut_M2M3_1x2" "layout")
layInst=dbCreateInst(layout mstr "" 2.525:2.06 "R0")
fig = dbCreateRect(layout list(42 -1) list(2.58:2.2 3.0:2.25))
dbCreateLabel(layout list(58 -1) 3.0:2.2 "CP<12>" "centerLeft" "R0" "stick" 0.1)
mstr = dbOpenCellViewByType( pdkLib "cut_M1M3_2x1" "layout")
layInst=dbCreateInst(layout mstr "" 3.0:1.735 "R0")
mstr = dbOpenCellViewByType( pdkLib "cut_M2M3_1x2" "layout")
layInst=dbCreateInst(layout mstr "" 2.525:1.595 "R0")
fig = dbCreateRect(layout list(42 -1) list(2.58:1.735 3.0:1.785))
dbCreateLabel(layout list(58 -1) 3.0:1.735 "CP<12>" "centerLeft" "R0" "stick" 0.1)
mstr = dbOpenCellViewByType( pdkLib "cut_M1M3_2x1" "layout")
layInst=dbCreateInst(layout mstr "" 3.0:0.805 "R0")
mstr = dbOpenCellViewByType( pdkLib "cut_M2M3_1x2" "layout")
layInst=dbCreateInst(layout mstr "" 2.525:0.665 "R0")
fig = dbCreateRect(layout list(42 -1) list(2.58:0.805 3.0:0.855))
dbCreateLabel(layout list(58 -1) 3.0:0.805 "CP<12>" "centerLeft" "R0" "stick" 0.1)
mstr = dbOpenCellViewByType( pdkLib "cut_M1M3_2x1" "layout")
layInst=dbCreateInst(layout mstr "" 3.0:21.305 "R0")
mstr = dbOpenCellViewByType( pdkLib "cut_M2M3_1x2" "layout")
layInst=dbCreateInst(layout mstr "" 2.525:21.165 "R0")
fig = dbCreateRect(layout list(42 -1) list(2.58:21.305 3.0:21.355))
dbCreateLabel(layout list(58 -1) 3.0:21.305 "CP<12>" "centerLeft" "R0" "stick" 0.1)
mstr = dbOpenCellViewByType( pdkLib "cut_M1M3_2x1" "layout")
layInst=dbCreateInst(layout mstr "" 3.0:23.63 "R0")
mstr = dbOpenCellViewByType( pdkLib "cut_M2M3_1x2" "layout")
layInst=dbCreateInst(layout mstr "" 2.525:23.49 "R0")
fig = dbCreateRect(layout list(42 -1) list(2.58:23.63 3.0:23.68))
dbCreateLabel(layout list(58 -1) 3.0:23.63 "CP<12>" "centerLeft" "R0" "stick" 0.1)
mstr = dbOpenCellViewByType( pdkLib "cut_M1M3_2x1" "layout")
layInst=dbCreateInst(layout mstr "" 3.0:22.235 "R0")
mstr = dbOpenCellViewByType( pdkLib "cut_M2M3_1x2" "layout")
layInst=dbCreateInst(layout mstr "" 2.525:22.095 "R0")
fig = dbCreateRect(layout list(42 -1) list(2.58:22.235 3.0:22.285))
dbCreateLabel(layout list(58 -1) 3.0:22.235 "CP<12>" "centerLeft" "R0" "stick" 0.1)
mstr = dbOpenCellViewByType( pdkLib "cut_M1M3_2x1" "layout")
layInst=dbCreateInst(layout mstr "" 3.0:23.165 "R0")
mstr = dbOpenCellViewByType( pdkLib "cut_M2M3_1x2" "layout")
layInst=dbCreateInst(layout mstr "" 2.525:23.025 "R0")
fig = dbCreateRect(layout list(42 -1) list(2.58:23.165 3.0:23.215))
dbCreateLabel(layout list(58 -1) 3.0:23.165 "CP<12>" "centerLeft" "R0" "stick" 0.1)
mstr = dbOpenCellViewByType( pdkLib "cut_M1M3_2x1" "layout")
layInst=dbCreateInst(layout mstr "" 3.0:22.7 "R0")
mstr = dbOpenCellViewByType( pdkLib "cut_M2M3_1x2" "layout")
layInst=dbCreateInst(layout mstr "" 2.525:22.56 "R0")
fig = dbCreateRect(layout list(42 -1) list(2.58:22.7 3.0:22.75))
dbCreateLabel(layout list(58 -1) 3.0:22.7 "CP<12>" "centerLeft" "R0" "stick" 0.1)
mstr = dbOpenCellViewByType( pdkLib "cut_M1M3_2x1" "layout")
layInst=dbCreateInst(layout mstr "" 3.0:21.77 "R0")
mstr = dbOpenCellViewByType( pdkLib "cut_M2M3_1x2" "layout")
layInst=dbCreateInst(layout mstr "" 2.525:21.63 "R0")
fig = dbCreateRect(layout list(42 -1) list(2.58:21.77 3.0:21.82))
dbCreateLabel(layout list(58 -1) 3.0:21.77 "CP<12>" "centerLeft" "R0" "stick" 0.1)
mstr = dbOpenCellViewByType( pdkLib "cut_M1M3_2x1" "layout")
layInst=dbCreateInst(layout mstr "" 3.0:27.295 "R0")
mstr = dbOpenCellViewByType( pdkLib "cut_M2M3_1x2" "layout")
layInst=dbCreateInst(layout mstr "" 2.525:27.155 "R0")
fig = dbCreateRect(layout list(42 -1) list(2.58:27.295 3.0:27.345))
dbCreateLabel(layout list(58 -1) 3.0:27.295 "CP<12>" "centerLeft" "R0" "stick" 0.1)
mstr = dbOpenCellViewByType( pdkLib "cut_M1M3_2x1" "layout")
layInst=dbCreateInst(layout mstr "" 3.0:29.62 "R0")
mstr = dbOpenCellViewByType( pdkLib "cut_M2M3_1x2" "layout")
layInst=dbCreateInst(layout mstr "" 2.525:29.48 "R0")
fig = dbCreateRect(layout list(42 -1) list(2.58:29.62 3.0:29.67))
dbCreateLabel(layout list(58 -1) 3.0:29.62 "CP<12>" "centerLeft" "R0" "stick" 0.1)
mstr = dbOpenCellViewByType( pdkLib "cut_M1M3_2x1" "layout")
layInst=dbCreateInst(layout mstr "" 3.0:28.225 "R0")
mstr = dbOpenCellViewByType( pdkLib "cut_M2M3_1x2" "layout")
layInst=dbCreateInst(layout mstr "" 2.525:28.085 "R0")
fig = dbCreateRect(layout list(42 -1) list(2.58:28.225 3.0:28.275))
dbCreateLabel(layout list(58 -1) 3.0:28.225 "CP<12>" "centerLeft" "R0" "stick" 0.1)
mstr = dbOpenCellViewByType( pdkLib "cut_M1M3_2x1" "layout")
layInst=dbCreateInst(layout mstr "" 3.0:29.155 "R0")
mstr = dbOpenCellViewByType( pdkLib "cut_M2M3_1x2" "layout")
layInst=dbCreateInst(layout mstr "" 2.525:29.015 "R0")
fig = dbCreateRect(layout list(42 -1) list(2.58:29.155 3.0:29.205))
dbCreateLabel(layout list(58 -1) 3.0:29.155 "CP<12>" "centerLeft" "R0" "stick" 0.1)
mstr = dbOpenCellViewByType( pdkLib "cut_M1M3_2x1" "layout")
layInst=dbCreateInst(layout mstr "" 3.0:28.69 "R0")
mstr = dbOpenCellViewByType( pdkLib "cut_M2M3_1x2" "layout")
layInst=dbCreateInst(layout mstr "" 2.525:28.55 "R0")
fig = dbCreateRect(layout list(42 -1) list(2.58:28.69 3.0:28.74))
dbCreateLabel(layout list(58 -1) 3.0:28.69 "CP<12>" "centerLeft" "R0" "stick" 0.1)
mstr = dbOpenCellViewByType( pdkLib "cut_M1M3_2x1" "layout")
layInst=dbCreateInst(layout mstr "" 3.0:27.76 "R0")
mstr = dbOpenCellViewByType( pdkLib "cut_M2M3_1x2" "layout")
layInst=dbCreateInst(layout mstr "" 2.525:27.62 "R0")
fig = dbCreateRect(layout list(42 -1) list(2.58:27.76 3.0:27.81))
dbCreateLabel(layout list(58 -1) 3.0:27.76 "CP<12>" "centerLeft" "R0" "stick" 0.1)
mstr = dbOpenCellViewByType( pdkLib "cut_M1M3_2x1" "layout")
layInst=dbCreateInst(layout mstr "" 3.0:45.265 "R0")
mstr = dbOpenCellViewByType( pdkLib "cut_M2M3_1x2" "layout")
layInst=dbCreateInst(layout mstr "" 2.525:45.125 "R0")
fig = dbCreateRect(layout list(42 -1) list(2.58:45.265 3.0:45.315))
dbCreateLabel(layout list(58 -1) 3.0:45.265 "CP<12>" "centerLeft" "R0" "stick" 0.1)
mstr = dbOpenCellViewByType( pdkLib "cut_M1M3_2x1" "layout")
layInst=dbCreateInst(layout mstr "" 3.0:47.59 "R0")
mstr = dbOpenCellViewByType( pdkLib "cut_M2M3_1x2" "layout")
layInst=dbCreateInst(layout mstr "" 2.525:47.45 "R0")
fig = dbCreateRect(layout list(42 -1) list(2.58:47.59 3.0:47.64))
dbCreateLabel(layout list(58 -1) 3.0:47.59 "CP<12>" "centerLeft" "R0" "stick" 0.1)
mstr = dbOpenCellViewByType( pdkLib "cut_M1M3_2x1" "layout")
layInst=dbCreateInst(layout mstr "" 3.0:46.195 "R0")
mstr = dbOpenCellViewByType( pdkLib "cut_M2M3_1x2" "layout")
layInst=dbCreateInst(layout mstr "" 2.525:46.055 "R0")
fig = dbCreateRect(layout list(42 -1) list(2.58:46.195 3.0:46.245))
dbCreateLabel(layout list(58 -1) 3.0:46.195 "CP<12>" "centerLeft" "R0" "stick" 0.1)
mstr = dbOpenCellViewByType( pdkLib "cut_M1M3_2x1" "layout")
layInst=dbCreateInst(layout mstr "" 3.0:47.125 "R0")
mstr = dbOpenCellViewByType( pdkLib "cut_M2M3_1x2" "layout")
layInst=dbCreateInst(layout mstr "" 2.525:46.985 "R0")
fig = dbCreateRect(layout list(42 -1) list(2.58:47.125 3.0:47.175))
dbCreateLabel(layout list(58 -1) 3.0:47.125 "CP<12>" "centerLeft" "R0" "stick" 0.1)
mstr = dbOpenCellViewByType( pdkLib "cut_M1M3_2x1" "layout")
layInst=dbCreateInst(layout mstr "" 3.0:46.66 "R0")
mstr = dbOpenCellViewByType( pdkLib "cut_M2M3_1x2" "layout")
layInst=dbCreateInst(layout mstr "" 2.525:46.52 "R0")
fig = dbCreateRect(layout list(42 -1) list(2.58:46.66 3.0:46.71))
dbCreateLabel(layout list(58 -1) 3.0:46.66 "CP<12>" "centerLeft" "R0" "stick" 0.1)
mstr = dbOpenCellViewByType( pdkLib "cut_M1M3_2x1" "layout")
layInst=dbCreateInst(layout mstr "" 3.0:45.73 "R0")
mstr = dbOpenCellViewByType( pdkLib "cut_M2M3_1x2" "layout")
layInst=dbCreateInst(layout mstr "" 2.525:45.59 "R0")
fig = dbCreateRect(layout list(42 -1) list(2.58:45.73 3.0:45.78))
dbCreateLabel(layout list(58 -1) 3.0:45.73 "CP<12>" "centerLeft" "R0" "stick" 0.1)
fig = dbCreateRect(layout list(36 -1) list(2.32:18.17 2.38:50.915))
net = dbCreateNet(layout "CP<11>")
dbCreateTerm( net "CP<11>" "inputOutput")
dbCreatePin(net fig)
dbCreateLabel(layout list(36 237) 2.32:18.17 "CP<11>" "centerLeft" "R0" "stick" 0.1)
fig = dbCreateRect(layout list(36 -1) list(2.32:18.17 2.38:50.915))
mstr = dbOpenCellViewByType( pdkLib "cut_M1M3_2x1" "layout")
layInst=dbCreateInst(layout mstr "" 3.0:18.31 "R0")
mstr = dbOpenCellViewByType( pdkLib "cut_M2M3_1x2" "layout")
layInst=dbCreateInst(layout mstr "" 2.325:18.17 "R0")
fig = dbCreateRect(layout list(42 -1) list(2.38:18.31 3.0:18.36))
dbCreateLabel(layout list(58 -1) 3.0:18.31 "CP<11>" "centerLeft" "R0" "stick" 0.1)
mstr = dbOpenCellViewByType( pdkLib "cut_M1M3_2x1" "layout")
layInst=dbCreateInst(layout mstr "" 3.0:20.635 "R0")
mstr = dbOpenCellViewByType( pdkLib "cut_M2M3_1x2" "layout")
layInst=dbCreateInst(layout mstr "" 2.325:20.495 "R0")
fig = dbCreateRect(layout list(42 -1) list(2.38:20.635 3.0:20.685))
dbCreateLabel(layout list(58 -1) 3.0:20.635 "CP<11>" "centerLeft" "R0" "stick" 0.1)
mstr = dbOpenCellViewByType( pdkLib "cut_M1M3_2x1" "layout")
layInst=dbCreateInst(layout mstr "" 3.0:19.24 "R0")
mstr = dbOpenCellViewByType( pdkLib "cut_M2M3_1x2" "layout")
layInst=dbCreateInst(layout mstr "" 2.325:19.1 "R0")
fig = dbCreateRect(layout list(42 -1) list(2.38:19.24 3.0:19.29))
dbCreateLabel(layout list(58 -1) 3.0:19.24 "CP<11>" "centerLeft" "R0" "stick" 0.1)
mstr = dbOpenCellViewByType( pdkLib "cut_M1M3_2x1" "layout")
layInst=dbCreateInst(layout mstr "" 3.0:20.17 "R0")
mstr = dbOpenCellViewByType( pdkLib "cut_M2M3_1x2" "layout")
layInst=dbCreateInst(layout mstr "" 2.325:20.03 "R0")
fig = dbCreateRect(layout list(42 -1) list(2.38:20.17 3.0:20.22))
dbCreateLabel(layout list(58 -1) 3.0:20.17 "CP<11>" "centerLeft" "R0" "stick" 0.1)
mstr = dbOpenCellViewByType( pdkLib "cut_M1M3_2x1" "layout")
layInst=dbCreateInst(layout mstr "" 3.0:19.705 "R0")
mstr = dbOpenCellViewByType( pdkLib "cut_M2M3_1x2" "layout")
layInst=dbCreateInst(layout mstr "" 2.325:19.565 "R0")
fig = dbCreateRect(layout list(42 -1) list(2.38:19.705 3.0:19.755))
dbCreateLabel(layout list(58 -1) 3.0:19.705 "CP<11>" "centerLeft" "R0" "stick" 0.1)
mstr = dbOpenCellViewByType( pdkLib "cut_M1M3_2x1" "layout")
layInst=dbCreateInst(layout mstr "" 3.0:18.775 "R0")
mstr = dbOpenCellViewByType( pdkLib "cut_M2M3_1x2" "layout")
layInst=dbCreateInst(layout mstr "" 2.325:18.635 "R0")
fig = dbCreateRect(layout list(42 -1) list(2.38:18.775 3.0:18.825))
dbCreateLabel(layout list(58 -1) 3.0:18.775 "CP<11>" "centerLeft" "R0" "stick" 0.1)
mstr = dbOpenCellViewByType( pdkLib "cut_M1M3_2x1" "layout")
layInst=dbCreateInst(layout mstr "" 3.0:42.27 "R0")
mstr = dbOpenCellViewByType( pdkLib "cut_M2M3_1x2" "layout")
layInst=dbCreateInst(layout mstr "" 2.325:42.13 "R0")
fig = dbCreateRect(layout list(42 -1) list(2.38:42.27 3.0:42.32))
dbCreateLabel(layout list(58 -1) 3.0:42.27 "CP<11>" "centerLeft" "R0" "stick" 0.1)
mstr = dbOpenCellViewByType( pdkLib "cut_M1M3_2x1" "layout")
layInst=dbCreateInst(layout mstr "" 3.0:44.595 "R0")
mstr = dbOpenCellViewByType( pdkLib "cut_M2M3_1x2" "layout")
layInst=dbCreateInst(layout mstr "" 2.325:44.455 "R0")
fig = dbCreateRect(layout list(42 -1) list(2.38:44.595 3.0:44.645))
dbCreateLabel(layout list(58 -1) 3.0:44.595 "CP<11>" "centerLeft" "R0" "stick" 0.1)
mstr = dbOpenCellViewByType( pdkLib "cut_M1M3_2x1" "layout")
layInst=dbCreateInst(layout mstr "" 3.0:43.2 "R0")
mstr = dbOpenCellViewByType( pdkLib "cut_M2M3_1x2" "layout")
layInst=dbCreateInst(layout mstr "" 2.325:43.06 "R0")
fig = dbCreateRect(layout list(42 -1) list(2.38:43.2 3.0:43.25))
dbCreateLabel(layout list(58 -1) 3.0:43.2 "CP<11>" "centerLeft" "R0" "stick" 0.1)
mstr = dbOpenCellViewByType( pdkLib "cut_M1M3_2x1" "layout")
layInst=dbCreateInst(layout mstr "" 3.0:44.13 "R0")
mstr = dbOpenCellViewByType( pdkLib "cut_M2M3_1x2" "layout")
layInst=dbCreateInst(layout mstr "" 2.325:43.99 "R0")
fig = dbCreateRect(layout list(42 -1) list(2.38:44.13 3.0:44.18))
dbCreateLabel(layout list(58 -1) 3.0:44.13 "CP<11>" "centerLeft" "R0" "stick" 0.1)
mstr = dbOpenCellViewByType( pdkLib "cut_M1M3_2x1" "layout")
layInst=dbCreateInst(layout mstr "" 3.0:43.665 "R0")
mstr = dbOpenCellViewByType( pdkLib "cut_M2M3_1x2" "layout")
layInst=dbCreateInst(layout mstr "" 2.325:43.525 "R0")
fig = dbCreateRect(layout list(42 -1) list(2.38:43.665 3.0:43.715))
dbCreateLabel(layout list(58 -1) 3.0:43.665 "CP<11>" "centerLeft" "R0" "stick" 0.1)
mstr = dbOpenCellViewByType( pdkLib "cut_M1M3_2x1" "layout")
layInst=dbCreateInst(layout mstr "" 3.0:42.735 "R0")
mstr = dbOpenCellViewByType( pdkLib "cut_M2M3_1x2" "layout")
layInst=dbCreateInst(layout mstr "" 2.325:42.595 "R0")
fig = dbCreateRect(layout list(42 -1) list(2.38:42.735 3.0:42.785))
dbCreateLabel(layout list(58 -1) 3.0:42.735 "CP<11>" "centerLeft" "R0" "stick" 0.1)
fig = dbCreateRect(layout list(36 -1) list(2.12:6.19 2.18:50.915))
net = dbCreateNet(layout "CP<10>")
dbCreateTerm( net "CP<10>" "inputOutput")
dbCreatePin(net fig)
dbCreateLabel(layout list(36 237) 2.12:6.19 "CP<10>" "centerLeft" "R0" "stick" 0.1)
fig = dbCreateRect(layout list(36 -1) list(2.12:6.19 2.18:50.915))
mstr = dbOpenCellViewByType( pdkLib "cut_M1M3_2x1" "layout")
layInst=dbCreateInst(layout mstr "" 3.0:6.33 "R0")
mstr = dbOpenCellViewByType( pdkLib "cut_M2M3_1x2" "layout")
layInst=dbCreateInst(layout mstr "" 2.125:6.19 "R0")
fig = dbCreateRect(layout list(42 -1) list(2.18:6.33 3.0:6.38))
dbCreateLabel(layout list(58 -1) 3.0:6.33 "CP<10>" "centerLeft" "R0" "stick" 0.1)
mstr = dbOpenCellViewByType( pdkLib "cut_M1M3_2x1" "layout")
layInst=dbCreateInst(layout mstr "" 3.0:8.655 "R0")
mstr = dbOpenCellViewByType( pdkLib "cut_M2M3_1x2" "layout")
layInst=dbCreateInst(layout mstr "" 2.125:8.515 "R0")
fig = dbCreateRect(layout list(42 -1) list(2.18:8.655 3.0:8.705))
dbCreateLabel(layout list(58 -1) 3.0:8.655 "CP<10>" "centerLeft" "R0" "stick" 0.1)
mstr = dbOpenCellViewByType( pdkLib "cut_M1M3_2x1" "layout")
layInst=dbCreateInst(layout mstr "" 3.0:7.26 "R0")
mstr = dbOpenCellViewByType( pdkLib "cut_M2M3_1x2" "layout")
layInst=dbCreateInst(layout mstr "" 2.125:7.12 "R0")
fig = dbCreateRect(layout list(42 -1) list(2.18:7.26 3.0:7.31))
dbCreateLabel(layout list(58 -1) 3.0:7.26 "CP<10>" "centerLeft" "R0" "stick" 0.1)
mstr = dbOpenCellViewByType( pdkLib "cut_M1M3_2x1" "layout")
layInst=dbCreateInst(layout mstr "" 3.0:8.19 "R0")
mstr = dbOpenCellViewByType( pdkLib "cut_M2M3_1x2" "layout")
layInst=dbCreateInst(layout mstr "" 2.125:8.05 "R0")
fig = dbCreateRect(layout list(42 -1) list(2.18:8.19 3.0:8.24))
dbCreateLabel(layout list(58 -1) 3.0:8.19 "CP<10>" "centerLeft" "R0" "stick" 0.1)
mstr = dbOpenCellViewByType( pdkLib "cut_M1M3_2x1" "layout")
layInst=dbCreateInst(layout mstr "" 3.0:7.725 "R0")
mstr = dbOpenCellViewByType( pdkLib "cut_M2M3_1x2" "layout")
layInst=dbCreateInst(layout mstr "" 2.125:7.585 "R0")
fig = dbCreateRect(layout list(42 -1) list(2.18:7.725 3.0:7.775))
dbCreateLabel(layout list(58 -1) 3.0:7.725 "CP<10>" "centerLeft" "R0" "stick" 0.1)
mstr = dbOpenCellViewByType( pdkLib "cut_M1M3_2x1" "layout")
layInst=dbCreateInst(layout mstr "" 3.0:6.795 "R0")
mstr = dbOpenCellViewByType( pdkLib "cut_M2M3_1x2" "layout")
layInst=dbCreateInst(layout mstr "" 2.125:6.655 "R0")
fig = dbCreateRect(layout list(42 -1) list(2.18:6.795 3.0:6.845))
dbCreateLabel(layout list(58 -1) 3.0:6.795 "CP<10>" "centerLeft" "R0" "stick" 0.1)
mstr = dbOpenCellViewByType( pdkLib "cut_M1M3_2x1" "layout")
layInst=dbCreateInst(layout mstr "" 3.0:33.285 "R0")
mstr = dbOpenCellViewByType( pdkLib "cut_M2M3_1x2" "layout")
layInst=dbCreateInst(layout mstr "" 2.125:33.145 "R0")
fig = dbCreateRect(layout list(42 -1) list(2.18:33.285 3.0:33.335))
dbCreateLabel(layout list(58 -1) 3.0:33.285 "CP<10>" "centerLeft" "R0" "stick" 0.1)
mstr = dbOpenCellViewByType( pdkLib "cut_M1M3_2x1" "layout")
layInst=dbCreateInst(layout mstr "" 3.0:35.61 "R0")
mstr = dbOpenCellViewByType( pdkLib "cut_M2M3_1x2" "layout")
layInst=dbCreateInst(layout mstr "" 2.125:35.47 "R0")
fig = dbCreateRect(layout list(42 -1) list(2.18:35.61 3.0:35.66))
dbCreateLabel(layout list(58 -1) 3.0:35.61 "CP<10>" "centerLeft" "R0" "stick" 0.1)
mstr = dbOpenCellViewByType( pdkLib "cut_M1M3_2x1" "layout")
layInst=dbCreateInst(layout mstr "" 3.0:34.215 "R0")
mstr = dbOpenCellViewByType( pdkLib "cut_M2M3_1x2" "layout")
layInst=dbCreateInst(layout mstr "" 2.125:34.075 "R0")
fig = dbCreateRect(layout list(42 -1) list(2.18:34.215 3.0:34.265))
dbCreateLabel(layout list(58 -1) 3.0:34.215 "CP<10>" "centerLeft" "R0" "stick" 0.1)
mstr = dbOpenCellViewByType( pdkLib "cut_M1M3_2x1" "layout")
layInst=dbCreateInst(layout mstr "" 3.0:35.145 "R0")
mstr = dbOpenCellViewByType( pdkLib "cut_M2M3_1x2" "layout")
layInst=dbCreateInst(layout mstr "" 2.125:35.005 "R0")
fig = dbCreateRect(layout list(42 -1) list(2.18:35.145 3.0:35.195))
dbCreateLabel(layout list(58 -1) 3.0:35.145 "CP<10>" "centerLeft" "R0" "stick" 0.1)
mstr = dbOpenCellViewByType( pdkLib "cut_M1M3_2x1" "layout")
layInst=dbCreateInst(layout mstr "" 3.0:34.68 "R0")
mstr = dbOpenCellViewByType( pdkLib "cut_M2M3_1x2" "layout")
layInst=dbCreateInst(layout mstr "" 2.125:34.54 "R0")
fig = dbCreateRect(layout list(42 -1) list(2.18:34.68 3.0:34.73))
dbCreateLabel(layout list(58 -1) 3.0:34.68 "CP<10>" "centerLeft" "R0" "stick" 0.1)
mstr = dbOpenCellViewByType( pdkLib "cut_M1M3_2x1" "layout")
layInst=dbCreateInst(layout mstr "" 3.0:33.75 "R0")
mstr = dbOpenCellViewByType( pdkLib "cut_M2M3_1x2" "layout")
layInst=dbCreateInst(layout mstr "" 2.125:33.61 "R0")
fig = dbCreateRect(layout list(42 -1) list(2.18:33.75 3.0:33.8))
dbCreateLabel(layout list(58 -1) 3.0:33.75 "CP<10>" "centerLeft" "R0" "stick" 0.1)
fig = dbCreateRect(layout list(36 -1) list(1.92:39.135 1.98:50.915))
net = dbCreateNet(layout "CP<9>")
dbCreateTerm( net "CP<9>" "inputOutput")
dbCreatePin(net fig)
dbCreateLabel(layout list(36 237) 1.92:39.135 "CP<9>" "centerLeft" "R0" "stick" 0.1)
fig = dbCreateRect(layout list(36 -1) list(1.92:39.135 1.98:50.915))
mstr = dbOpenCellViewByType( pdkLib "cut_M1M3_2x1" "layout")
layInst=dbCreateInst(layout mstr "" 3.0:39.275 "R0")
mstr = dbOpenCellViewByType( pdkLib "cut_M2M3_1x2" "layout")
layInst=dbCreateInst(layout mstr "" 1.925:39.135 "R0")
fig = dbCreateRect(layout list(42 -1) list(1.98:39.275 3.0:39.325))
dbCreateLabel(layout list(58 -1) 3.0:39.275 "CP<9>" "centerLeft" "R0" "stick" 0.1)
mstr = dbOpenCellViewByType( pdkLib "cut_M1M3_2x1" "layout")
layInst=dbCreateInst(layout mstr "" 3.0:41.6 "R0")
mstr = dbOpenCellViewByType( pdkLib "cut_M2M3_1x2" "layout")
layInst=dbCreateInst(layout mstr "" 1.925:41.46 "R0")
fig = dbCreateRect(layout list(42 -1) list(1.98:41.6 3.0:41.65))
dbCreateLabel(layout list(58 -1) 3.0:41.6 "CP<9>" "centerLeft" "R0" "stick" 0.1)
mstr = dbOpenCellViewByType( pdkLib "cut_M1M3_2x1" "layout")
layInst=dbCreateInst(layout mstr "" 3.0:40.205 "R0")
mstr = dbOpenCellViewByType( pdkLib "cut_M2M3_1x2" "layout")
layInst=dbCreateInst(layout mstr "" 1.925:40.065 "R0")
fig = dbCreateRect(layout list(42 -1) list(1.98:40.205 3.0:40.255))
dbCreateLabel(layout list(58 -1) 3.0:40.205 "CP<9>" "centerLeft" "R0" "stick" 0.1)
mstr = dbOpenCellViewByType( pdkLib "cut_M1M3_2x1" "layout")
layInst=dbCreateInst(layout mstr "" 3.0:41.135 "R0")
mstr = dbOpenCellViewByType( pdkLib "cut_M2M3_1x2" "layout")
layInst=dbCreateInst(layout mstr "" 1.925:40.995 "R0")
fig = dbCreateRect(layout list(42 -1) list(1.98:41.135 3.0:41.185))
dbCreateLabel(layout list(58 -1) 3.0:41.135 "CP<9>" "centerLeft" "R0" "stick" 0.1)
mstr = dbOpenCellViewByType( pdkLib "cut_M1M3_2x1" "layout")
layInst=dbCreateInst(layout mstr "" 3.0:40.67 "R0")
mstr = dbOpenCellViewByType( pdkLib "cut_M2M3_1x2" "layout")
layInst=dbCreateInst(layout mstr "" 1.925:40.53 "R0")
fig = dbCreateRect(layout list(42 -1) list(1.98:40.67 3.0:40.72))
dbCreateLabel(layout list(58 -1) 3.0:40.67 "CP<9>" "centerLeft" "R0" "stick" 0.1)
mstr = dbOpenCellViewByType( pdkLib "cut_M1M3_2x1" "layout")
layInst=dbCreateInst(layout mstr "" 3.0:39.74 "R0")
mstr = dbOpenCellViewByType( pdkLib "cut_M2M3_1x2" "layout")
layInst=dbCreateInst(layout mstr "" 1.925:39.6 "R0")
fig = dbCreateRect(layout list(42 -1) list(1.98:39.74 3.0:39.79))
dbCreateLabel(layout list(58 -1) 3.0:39.74 "CP<9>" "centerLeft" "R0" "stick" 0.1)
fig = dbCreateRect(layout list(36 -1) list(1.72:9.185 1.78:50.915))
net = dbCreateNet(layout "CP<8>")
dbCreateTerm( net "CP<8>" "inputOutput")
dbCreatePin(net fig)
dbCreateLabel(layout list(36 237) 1.72:9.185 "CP<8>" "centerLeft" "R0" "stick" 0.1)
fig = dbCreateRect(layout list(36 -1) list(1.72:9.185 1.78:50.915))
mstr = dbOpenCellViewByType( pdkLib "cut_M1M3_2x1" "layout")
layInst=dbCreateInst(layout mstr "" 3.0:9.325 "R0")
mstr = dbOpenCellViewByType( pdkLib "cut_M2M3_1x2" "layout")
layInst=dbCreateInst(layout mstr "" 1.725:9.185 "R0")
fig = dbCreateRect(layout list(42 -1) list(1.78:9.325 3.0:9.375))
dbCreateLabel(layout list(58 -1) 3.0:9.325 "CP<8>" "centerLeft" "R0" "stick" 0.1)
mstr = dbOpenCellViewByType( pdkLib "cut_M1M3_2x1" "layout")
layInst=dbCreateInst(layout mstr "" 3.0:11.65 "R0")
mstr = dbOpenCellViewByType( pdkLib "cut_M2M3_1x2" "layout")
layInst=dbCreateInst(layout mstr "" 1.725:11.51 "R0")
fig = dbCreateRect(layout list(42 -1) list(1.78:11.65 3.0:11.7))
dbCreateLabel(layout list(58 -1) 3.0:11.65 "CP<8>" "centerLeft" "R0" "stick" 0.1)
mstr = dbOpenCellViewByType( pdkLib "cut_M1M3_2x1" "layout")
layInst=dbCreateInst(layout mstr "" 3.0:10.255 "R0")
mstr = dbOpenCellViewByType( pdkLib "cut_M2M3_1x2" "layout")
layInst=dbCreateInst(layout mstr "" 1.725:10.115 "R0")
fig = dbCreateRect(layout list(42 -1) list(1.78:10.255 3.0:10.305))
dbCreateLabel(layout list(58 -1) 3.0:10.255 "CP<8>" "centerLeft" "R0" "stick" 0.1)
mstr = dbOpenCellViewByType( pdkLib "cut_M1M3_2x1" "layout")
layInst=dbCreateInst(layout mstr "" 3.0:11.185 "R0")
mstr = dbOpenCellViewByType( pdkLib "cut_M2M3_1x2" "layout")
layInst=dbCreateInst(layout mstr "" 1.725:11.045 "R0")
fig = dbCreateRect(layout list(42 -1) list(1.78:11.185 3.0:11.235))
dbCreateLabel(layout list(58 -1) 3.0:11.185 "CP<8>" "centerLeft" "R0" "stick" 0.1)
mstr = dbOpenCellViewByType( pdkLib "cut_M1M3_2x1" "layout")
layInst=dbCreateInst(layout mstr "" 3.0:10.72 "R0")
mstr = dbOpenCellViewByType( pdkLib "cut_M2M3_1x2" "layout")
layInst=dbCreateInst(layout mstr "" 1.725:10.58 "R0")
fig = dbCreateRect(layout list(42 -1) list(1.78:10.72 3.0:10.77))
dbCreateLabel(layout list(58 -1) 3.0:10.72 "CP<8>" "centerLeft" "R0" "stick" 0.1)
mstr = dbOpenCellViewByType( pdkLib "cut_M1M3_2x1" "layout")
layInst=dbCreateInst(layout mstr "" 3.0:9.79 "R0")
mstr = dbOpenCellViewByType( pdkLib "cut_M2M3_1x2" "layout")
layInst=dbCreateInst(layout mstr "" 1.725:9.65 "R0")
fig = dbCreateRect(layout list(42 -1) list(1.78:9.79 3.0:9.84))
dbCreateLabel(layout list(58 -1) 3.0:9.79 "CP<8>" "centerLeft" "R0" "stick" 0.1)
fig = dbCreateRect(layout list(36 -1) list(1.52:12.645 1.58:50.915))
net = dbCreateNet(layout "CP<7>")
dbCreateTerm( net "CP<7>" "inputOutput")
dbCreatePin(net fig)
dbCreateLabel(layout list(36 237) 1.52:12.645 "CP<7>" "centerLeft" "R0" "stick" 0.1)
fig = dbCreateRect(layout list(36 -1) list(1.52:12.645 1.58:50.915))
mstr = dbOpenCellViewByType( pdkLib "cut_M1M3_2x1" "layout")
layInst=dbCreateInst(layout mstr "" 3.0:12.785 "R0")
mstr = dbOpenCellViewByType( pdkLib "cut_M2M3_1x2" "layout")
layInst=dbCreateInst(layout mstr "" 1.525:12.645 "R0")
fig = dbCreateRect(layout list(42 -1) list(1.58:12.785 3.0:12.835))
dbCreateLabel(layout list(58 -1) 3.0:12.785 "CP<7>" "centerLeft" "R0" "stick" 0.1)
fig = dbCreateRect(layout list(36 -1) list(1.32:12.18 1.38:50.915))
net = dbCreateNet(layout "CP<6>")
dbCreateTerm( net "CP<6>" "inputOutput")
dbCreatePin(net fig)
dbCreateLabel(layout list(36 237) 1.32:12.18 "CP<6>" "centerLeft" "R0" "stick" 0.1)
fig = dbCreateRect(layout list(36 -1) list(1.32:12.18 1.38:50.915))
mstr = dbOpenCellViewByType( pdkLib "cut_M1M3_2x1" "layout")
layInst=dbCreateInst(layout mstr "" 3.0:12.32 "R0")
mstr = dbOpenCellViewByType( pdkLib "cut_M2M3_1x2" "layout")
layInst=dbCreateInst(layout mstr "" 1.325:12.18 "R0")
fig = dbCreateRect(layout list(42 -1) list(1.38:12.32 3.0:12.37))
dbCreateLabel(layout list(58 -1) 3.0:12.32 "CP<6>" "centerLeft" "R0" "stick" 0.1)
mstr = dbOpenCellViewByType( pdkLib "cut_M1M3_2x1" "layout")
layInst=dbCreateInst(layout mstr "" 3.0:14.645 "R0")
mstr = dbOpenCellViewByType( pdkLib "cut_M2M3_1x2" "layout")
layInst=dbCreateInst(layout mstr "" 1.325:14.505 "R0")
fig = dbCreateRect(layout list(42 -1) list(1.38:14.645 3.0:14.695))
dbCreateLabel(layout list(58 -1) 3.0:14.645 "CP<6>" "centerLeft" "R0" "stick" 0.1)
mstr = dbOpenCellViewByType( pdkLib "cut_M1M3_2x1" "layout")
layInst=dbCreateInst(layout mstr "" 3.0:13.25 "R0")
mstr = dbOpenCellViewByType( pdkLib "cut_M2M3_1x2" "layout")
layInst=dbCreateInst(layout mstr "" 1.325:13.11 "R0")
fig = dbCreateRect(layout list(42 -1) list(1.38:13.25 3.0:13.3))
dbCreateLabel(layout list(58 -1) 3.0:13.25 "CP<6>" "centerLeft" "R0" "stick" 0.1)
mstr = dbOpenCellViewByType( pdkLib "cut_M1M3_2x1" "layout")
layInst=dbCreateInst(layout mstr "" 3.0:14.18 "R0")
mstr = dbOpenCellViewByType( pdkLib "cut_M2M3_1x2" "layout")
layInst=dbCreateInst(layout mstr "" 1.325:14.04 "R0")
fig = dbCreateRect(layout list(42 -1) list(1.38:14.18 3.0:14.23))
dbCreateLabel(layout list(58 -1) 3.0:14.18 "CP<6>" "centerLeft" "R0" "stick" 0.1)
mstr = dbOpenCellViewByType( pdkLib "cut_M1M3_2x1" "layout")
layInst=dbCreateInst(layout mstr "" 3.0:13.715 "R0")
mstr = dbOpenCellViewByType( pdkLib "cut_M2M3_1x2" "layout")
layInst=dbCreateInst(layout mstr "" 1.325:13.575 "R0")
fig = dbCreateRect(layout list(42 -1) list(1.38:13.715 3.0:13.765))
dbCreateLabel(layout list(58 -1) 3.0:13.715 "CP<6>" "centerLeft" "R0" "stick" 0.1)
fig = dbCreateRect(layout list(36 -1) list(1.12:36.14 1.18:50.915))
net = dbCreateNet(layout "CP<5>")
dbCreateTerm( net "CP<5>" "inputOutput")
dbCreatePin(net fig)
dbCreateLabel(layout list(36 237) 1.12:36.14 "CP<5>" "centerLeft" "R0" "stick" 0.1)
fig = dbCreateRect(layout list(36 -1) list(1.12:36.14 1.18:50.915))
mstr = dbOpenCellViewByType( pdkLib "cut_M1M3_2x1" "layout")
layInst=dbCreateInst(layout mstr "" 3.0:36.28 "R0")
mstr = dbOpenCellViewByType( pdkLib "cut_M2M3_1x2" "layout")
layInst=dbCreateInst(layout mstr "" 1.125:36.14 "R0")
fig = dbCreateRect(layout list(42 -1) list(1.18:36.28 3.0:36.33))
dbCreateLabel(layout list(58 -1) 3.0:36.28 "CP<5>" "centerLeft" "R0" "stick" 0.1)
mstr = dbOpenCellViewByType( pdkLib "cut_M1M3_2x1" "layout")
layInst=dbCreateInst(layout mstr "" 3.0:38.605 "R0")
mstr = dbOpenCellViewByType( pdkLib "cut_M2M3_1x2" "layout")
layInst=dbCreateInst(layout mstr "" 1.125:38.465 "R0")
fig = dbCreateRect(layout list(42 -1) list(1.18:38.605 3.0:38.655))
dbCreateLabel(layout list(58 -1) 3.0:38.605 "CP<5>" "centerLeft" "R0" "stick" 0.1)
mstr = dbOpenCellViewByType( pdkLib "cut_M1M3_2x1" "layout")
layInst=dbCreateInst(layout mstr "" 3.0:37.21 "R0")
mstr = dbOpenCellViewByType( pdkLib "cut_M2M3_1x2" "layout")
layInst=dbCreateInst(layout mstr "" 1.125:37.07 "R0")
fig = dbCreateRect(layout list(42 -1) list(1.18:37.21 3.0:37.26))
dbCreateLabel(layout list(58 -1) 3.0:37.21 "CP<5>" "centerLeft" "R0" "stick" 0.1)
mstr = dbOpenCellViewByType( pdkLib "cut_M1M3_2x1" "layout")
layInst=dbCreateInst(layout mstr "" 3.0:38.14 "R0")
mstr = dbOpenCellViewByType( pdkLib "cut_M2M3_1x2" "layout")
layInst=dbCreateInst(layout mstr "" 1.125:38.0 "R0")
fig = dbCreateRect(layout list(42 -1) list(1.18:38.14 3.0:38.19))
dbCreateLabel(layout list(58 -1) 3.0:38.14 "CP<5>" "centerLeft" "R0" "stick" 0.1)
fig = dbCreateRect(layout list(36 -1) list(0.92:37.535 0.98:50.915))
net = dbCreateNet(layout "CP<4>")
dbCreateTerm( net "CP<4>" "inputOutput")
dbCreatePin(net fig)
dbCreateLabel(layout list(36 237) 0.92:37.535 "CP<4>" "centerLeft" "R0" "stick" 0.1)
fig = dbCreateRect(layout list(36 -1) list(0.92:37.535 0.98:50.915))
mstr = dbOpenCellViewByType( pdkLib "cut_M1M3_2x1" "layout")
layInst=dbCreateInst(layout mstr "" 3.0:37.675 "R0")
mstr = dbOpenCellViewByType( pdkLib "cut_M2M3_1x2" "layout")
layInst=dbCreateInst(layout mstr "" 0.925:37.535 "R0")
fig = dbCreateRect(layout list(42 -1) list(0.98:37.675 3.0:37.725))
dbCreateLabel(layout list(58 -1) 3.0:37.675 "CP<4>" "centerLeft" "R0" "stick" 0.1)
fig = dbCreateRect(layout list(36 -1) list(0.72:16.57 0.78:50.915))
net = dbCreateNet(layout "CP<3>")
dbCreateTerm( net "CP<3>" "inputOutput")
dbCreatePin(net fig)
dbCreateLabel(layout list(36 237) 0.72:16.57 "CP<3>" "centerLeft" "R0" "stick" 0.1)
fig = dbCreateRect(layout list(36 -1) list(0.72:16.57 0.78:50.915))
mstr = dbOpenCellViewByType( pdkLib "cut_M1M3_2x1" "layout")
layInst=dbCreateInst(layout mstr "" 3.0:16.71 "R0")
mstr = dbOpenCellViewByType( pdkLib "cut_M2M3_1x2" "layout")
layInst=dbCreateInst(layout mstr "" 0.725:16.57 "R0")
fig = dbCreateRect(layout list(42 -1) list(0.78:16.71 3.0:16.76))
dbCreateLabel(layout list(58 -1) 3.0:16.71 "CP<3>" "centerLeft" "R0" "stick" 0.1)
fig = dbCreateRect(layout list(36 -1) list(0.52:17.035 0.58:50.915))
net = dbCreateNet(layout "CP<2>")
dbCreateTerm( net "CP<2>" "inputOutput")
dbCreatePin(net fig)
dbCreateLabel(layout list(36 237) 0.52:17.035 "CP<2>" "centerLeft" "R0" "stick" 0.1)
fig = dbCreateRect(layout list(36 -1) list(0.52:17.035 0.58:50.915))
mstr = dbOpenCellViewByType( pdkLib "cut_M1M3_2x1" "layout")
layInst=dbCreateInst(layout mstr "" 3.0:17.175 "R0")
mstr = dbOpenCellViewByType( pdkLib "cut_M2M3_1x2" "layout")
layInst=dbCreateInst(layout mstr "" 0.525:17.035 "R0")
fig = dbCreateRect(layout list(42 -1) list(0.58:17.175 3.0:17.225))
dbCreateLabel(layout list(58 -1) 3.0:17.175 "CP<2>" "centerLeft" "R0" "stick" 0.1)
fig = dbCreateRect(layout list(36 -1) list(0.32:16.105 0.38:50.915))
net = dbCreateNet(layout "CP<1>")
dbCreateTerm( net "CP<1>" "inputOutput")
dbCreatePin(net fig)
dbCreateLabel(layout list(36 237) 0.32:16.105 "CP<1>" "centerLeft" "R0" "stick" 0.1)
fig = dbCreateRect(layout list(36 -1) list(0.32:16.105 0.38:50.915))
mstr = dbOpenCellViewByType( pdkLib "cut_M1M3_2x1" "layout")
layInst=dbCreateInst(layout mstr "" 3.0:16.245 "R0")
mstr = dbOpenCellViewByType( pdkLib "cut_M2M3_1x2" "layout")
layInst=dbCreateInst(layout mstr "" 0.325:16.105 "R0")
fig = dbCreateRect(layout list(42 -1) list(0.38:16.245 3.0:16.295))
dbCreateLabel(layout list(58 -1) 3.0:16.245 "CP<1>" "centerLeft" "R0" "stick" 0.1)
fig = dbCreateRect(layout list(36 -1) list(0.12:17.5 0.18:50.915))
net = dbCreateNet(layout "CP<0>")
dbCreateTerm( net "CP<0>" "inputOutput")
dbCreatePin(net fig)
dbCreateLabel(layout list(36 237) 0.12:17.5 "CP<0>" "centerLeft" "R0" "stick" 0.1)
fig = dbCreateRect(layout list(36 -1) list(0.12:17.5 0.18:50.915))
mstr = dbOpenCellViewByType( pdkLib "cut_M1M3_2x1" "layout")
layInst=dbCreateInst(layout mstr "" 3.0:17.64 "R0")
mstr = dbOpenCellViewByType( pdkLib "cut_M2M3_1x2" "layout")
layInst=dbCreateInst(layout mstr "" 0.125:17.5 "R0")
fig = dbCreateRect(layout list(42 -1) list(0.18:17.64 3.0:17.69))
dbCreateLabel(layout list(58 -1) 3.0:17.64 "CP<0>" "centerLeft" "R0" "stick" 0.1)
fig = dbCreateRect(layout list(34 -1) list(3.0:15.175 3.05:15.505))
fig = dbCreateRect(layout list(35 -1) list(3.0:15.25 3.05:15.3))
fig = dbCreateRect(layout list(35 -1) list(3.0:15.38 3.05:15.43))
fig = dbCreateRect(layout list(36 -1) list(3.0:15.175 3.05:15.505))
fig = dbCreateRect(layout list(36 -1) list(3.0:15.315 3.63:15.365))
fig = dbCreateRect(layout list(34 -1) list(3.0:15.64 3.05:15.97))
fig = dbCreateRect(layout list(35 -1) list(3.0:15.715 3.05:15.765))
fig = dbCreateRect(layout list(35 -1) list(3.0:15.845 3.05:15.895))
fig = dbCreateRect(layout list(36 -1) list(3.0:15.64 3.05:15.97))
fig = dbCreateRect(layout list(36 -1) list(3.0:15.78 3.63:15.83))
fig = dbCreateRect(layout list(34 -1) list(3.0:36.605 3.05:36.935))
fig = dbCreateRect(layout list(35 -1) list(3.0:36.68 3.05:36.73))
fig = dbCreateRect(layout list(35 -1) list(3.0:36.81 3.05:36.86))
fig = dbCreateRect(layout list(36 -1) list(3.0:36.605 3.05:36.935))
fig = dbCreateRect(layout list(36 -1) list(3.0:36.745 3.63:36.795))
fig = dbCreateRect(layout list(36 -1) list(3.63:0.0 16.63:0.05))
net = dbCreateNet(layout "AVSS")
dbCreateTerm( net "AVSS" "inputOutput")
dbCreatePin(net fig)
dbCreateLabel(layout list(36 237) 3.63:0.0 "AVSS" "centerLeft" "R0" "stick" 0.1)
fig = dbCreateRect(layout list(46 -1) list(3.63:47.92 3.68:50.975))
net = dbCreateNet(layout "CTOP")
dbCreateTerm( net "CTOP" "inputOutput")
dbCreatePin(net fig)
dbCreateLabel(layout list(46 237) 3.63:47.92 "CTOP" "centerLeft" "R0" "stick" 0.1)
 dbSave(layout) )
