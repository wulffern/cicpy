gdssLibName = "SAR9B"
 pdkLib = "SAR9B"
;- Create cell CAP32C_CV
(let (layout net fig )
 layout = dbOpenCellViewByType(gdssLibName "CAP32C_CV" "layout" "maskLayout" "w")
mstr = dbOpenCellViewByType( pdkLib "RM1" "layout")
layInst=dbCreateInst(layout mstr "XRES1A" 0.33:0.34 "R0")
mstr = dbOpenCellViewByType( pdkLib "RM1" "layout")
layInst=dbCreateInst(layout mstr "XRES1B" 0.33:2.665 "R0")
mstr = dbOpenCellViewByType( pdkLib "RM1" "layout")
layInst=dbCreateInst(layout mstr "XRES2" 0.33:1.27 "R0")
mstr = dbOpenCellViewByType( pdkLib "RM1" "layout")
layInst=dbCreateInst(layout mstr "XRES4" 0.33:2.2 "R0")
mstr = dbOpenCellViewByType( pdkLib "RM1" "layout")
layInst=dbCreateInst(layout mstr "XRES8" 0.33:1.735 "R0")
mstr = dbOpenCellViewByType( pdkLib "RM1" "layout")
layInst=dbCreateInst(layout mstr "XRES16" 0.33:0.805 "R0")
fig = dbCreateRect(layout list(46 -1) list(0.63:0.0 0.68:3.055))
net = dbCreateNet(layout "CTOP")
dbCreateTerm( net "CTOP" "inputOutput")
dbCreatePin(net fig)
dbCreateLabel(layout list(46 237) 0.63:0.0 "CTOP" "centerLeft" "R0" "stick" 0.1)
mstr = dbOpenCellViewByType( pdkLib "cut_M2M4_1x2" "layout")
layInst=dbCreateInst(layout mstr "" 13.63:1.1975 "R0")
fig = dbCreateRect(layout list(36 -1) list(0.63:0.0 13.63:0.05))
net = dbCreateNet(layout "AVSS")
dbCreateTerm( net "AVSS" "inputOutput")
dbCreatePin(net fig)
dbCreateLabel(layout list(36 237) 0.63:0.0 "AVSS" "centerLeft" "R0" "stick" 0.1)
fig = dbCreateRect(layout list(34 -1) list(0.0:0.34 0.33:0.39))
net = dbCreateNet(layout "C1A")
dbCreateTerm( net "C1A" "inputOutput")
dbCreatePin(net fig)
dbCreateLabel(layout list(34 237) 0.0:0.34 "C1A" "centerLeft" "R0" "stick" 0.1)
fig = dbCreateRect(layout list(34 -1) list(0.0:2.665 0.33:2.715))
net = dbCreateNet(layout "C1B")
dbCreateTerm( net "C1B" "inputOutput")
dbCreatePin(net fig)
dbCreateLabel(layout list(34 237) 0.0:2.665 "C1B" "centerLeft" "R0" "stick" 0.1)
fig = dbCreateRect(layout list(34 -1) list(0.0:1.27 0.33:1.32))
net = dbCreateNet(layout "C2")
dbCreateTerm( net "C2" "inputOutput")
dbCreatePin(net fig)
dbCreateLabel(layout list(34 237) 0.0:1.27 "C2" "centerLeft" "R0" "stick" 0.1)
fig = dbCreateRect(layout list(34 -1) list(0.0:2.2 0.33:2.25))
net = dbCreateNet(layout "C4")
dbCreateTerm( net "C4" "inputOutput")
dbCreatePin(net fig)
dbCreateLabel(layout list(34 237) 0.0:2.2 "C4" "centerLeft" "R0" "stick" 0.1)
fig = dbCreateRect(layout list(34 -1) list(0.0:1.735 0.33:1.785))
net = dbCreateNet(layout "C8")
dbCreateTerm( net "C8" "inputOutput")
dbCreatePin(net fig)
dbCreateLabel(layout list(34 237) 0.0:1.735 "C8" "centerLeft" "R0" "stick" 0.1)
fig = dbCreateRect(layout list(34 -1) list(0.0:0.805 0.33:0.855))
net = dbCreateNet(layout "C16")
dbCreateTerm( net "C16" "inputOutput")
dbCreatePin(net fig)
dbCreateLabel(layout list(34 237) 0.0:0.805 "C16" "centerLeft" "R0" "stick" 0.1)
mstr = dbOpenCellViewByType( pdkLib "cut_M1M4_1x2" "layout")
layInst=dbCreateInst(layout mstr "" 3.63:0.2 "R0")
fig = dbCreateRect(layout list(36 -1) list(3.63:0.0 3.68:0.13))
fig = dbCreateRect(layout list(36 -1) list(3.63:0.6 3.68:3.055))
mstr = dbOpenCellViewByType( pdkLib "cut_M1M4_1x2" "layout")
layInst=dbCreateInst(layout mstr "" 10.43:2.525 "R0")
fig = dbCreateRect(layout list(36 -1) list(10.43:0.0 10.48:2.455))
fig = dbCreateRect(layout list(36 -1) list(10.43:2.925 10.48:3.055))
mstr = dbOpenCellViewByType( pdkLib "cut_M1M4_1x2" "layout")
layInst=dbCreateInst(layout mstr "" 4.03:1.13 "R0")
fig = dbCreateRect(layout list(36 -1) list(4.03:0.0 4.08:1.06))
fig = dbCreateRect(layout list(36 -1) list(4.03:1.53 4.08:3.055))
mstr = dbOpenCellViewByType( pdkLib "cut_M1M4_1x2" "layout")
layInst=dbCreateInst(layout mstr "" 10.03:1.13 "R0")
fig = dbCreateRect(layout list(36 -1) list(10.03:0.0 10.08:1.06))
fig = dbCreateRect(layout list(36 -1) list(10.03:1.53 10.08:3.055))
mstr = dbOpenCellViewByType( pdkLib "cut_M1M4_1x2" "layout")
layInst=dbCreateInst(layout mstr "" 3.23:2.06 "R0")
fig = dbCreateRect(layout list(36 -1) list(3.23:0.0 3.28:1.99))
fig = dbCreateRect(layout list(36 -1) list(3.23:2.46 3.28:3.055))
mstr = dbOpenCellViewByType( pdkLib "cut_M1M4_1x2" "layout")
layInst=dbCreateInst(layout mstr "" 4.43:2.06 "R0")
fig = dbCreateRect(layout list(36 -1) list(4.43:0.0 4.48:1.99))
fig = dbCreateRect(layout list(36 -1) list(4.43:2.46 4.48:3.055))
mstr = dbOpenCellViewByType( pdkLib "cut_M1M4_1x2" "layout")
layInst=dbCreateInst(layout mstr "" 9.63:2.06 "R0")
fig = dbCreateRect(layout list(36 -1) list(9.63:0.0 9.68:1.99))
fig = dbCreateRect(layout list(36 -1) list(9.63:2.46 9.68:3.055))
mstr = dbOpenCellViewByType( pdkLib "cut_M1M4_1x2" "layout")
layInst=dbCreateInst(layout mstr "" 10.83:2.06 "R0")
fig = dbCreateRect(layout list(36 -1) list(10.83:0.0 10.88:1.99))
fig = dbCreateRect(layout list(36 -1) list(10.83:2.46 10.88:3.055))
mstr = dbOpenCellViewByType( pdkLib "cut_M1M4_1x2" "layout")
layInst=dbCreateInst(layout mstr "" 2.43:1.595 "R0")
fig = dbCreateRect(layout list(36 -1) list(2.43:0.0 2.48:1.525))
fig = dbCreateRect(layout list(36 -1) list(2.43:1.995 2.48:3.055))
mstr = dbOpenCellViewByType( pdkLib "cut_M1M4_1x2" "layout")
layInst=dbCreateInst(layout mstr "" 2.83:1.595 "R0")
fig = dbCreateRect(layout list(36 -1) list(2.83:0.0 2.88:1.525))
fig = dbCreateRect(layout list(36 -1) list(2.83:1.995 2.88:3.055))
mstr = dbOpenCellViewByType( pdkLib "cut_M1M4_1x2" "layout")
layInst=dbCreateInst(layout mstr "" 4.83:1.595 "R0")
fig = dbCreateRect(layout list(36 -1) list(4.83:0.0 4.88:1.525))
fig = dbCreateRect(layout list(36 -1) list(4.83:1.995 4.88:3.055))
mstr = dbOpenCellViewByType( pdkLib "cut_M1M4_1x2" "layout")
layInst=dbCreateInst(layout mstr "" 5.23:1.595 "R0")
fig = dbCreateRect(layout list(36 -1) list(5.23:0.0 5.28:1.525))
fig = dbCreateRect(layout list(36 -1) list(5.23:1.995 5.28:3.055))
mstr = dbOpenCellViewByType( pdkLib "cut_M1M4_1x2" "layout")
layInst=dbCreateInst(layout mstr "" 8.83:1.595 "R0")
fig = dbCreateRect(layout list(36 -1) list(8.83:0.0 8.88:1.525))
fig = dbCreateRect(layout list(36 -1) list(8.83:1.995 8.88:3.055))
mstr = dbOpenCellViewByType( pdkLib "cut_M1M4_1x2" "layout")
layInst=dbCreateInst(layout mstr "" 9.23:1.595 "R0")
fig = dbCreateRect(layout list(36 -1) list(9.23:0.0 9.28:1.525))
fig = dbCreateRect(layout list(36 -1) list(9.23:1.995 9.28:3.055))
mstr = dbOpenCellViewByType( pdkLib "cut_M1M4_1x2" "layout")
layInst=dbCreateInst(layout mstr "" 11.23:1.595 "R0")
fig = dbCreateRect(layout list(36 -1) list(11.23:0.0 11.28:1.525))
fig = dbCreateRect(layout list(36 -1) list(11.23:1.995 11.28:3.055))
mstr = dbOpenCellViewByType( pdkLib "cut_M1M4_1x2" "layout")
layInst=dbCreateInst(layout mstr "" 11.63:1.595 "R0")
fig = dbCreateRect(layout list(36 -1) list(11.63:0.0 11.68:1.525))
fig = dbCreateRect(layout list(36 -1) list(11.63:1.995 11.68:3.055))
mstr = dbOpenCellViewByType( pdkLib "cut_M1M4_1x2" "layout")
layInst=dbCreateInst(layout mstr "" 0.83:0.665 "R0")
fig = dbCreateRect(layout list(36 -1) list(0.83:0.0 0.88:0.595))
fig = dbCreateRect(layout list(36 -1) list(0.83:1.065 0.88:3.055))
mstr = dbOpenCellViewByType( pdkLib "cut_M1M4_1x2" "layout")
layInst=dbCreateInst(layout mstr "" 1.23:0.665 "R0")
fig = dbCreateRect(layout list(36 -1) list(1.23:0.0 1.28:0.595))
fig = dbCreateRect(layout list(36 -1) list(1.23:1.065 1.28:3.055))
mstr = dbOpenCellViewByType( pdkLib "cut_M1M4_1x2" "layout")
layInst=dbCreateInst(layout mstr "" 1.63:0.665 "R0")
fig = dbCreateRect(layout list(36 -1) list(1.63:0.0 1.68:0.595))
fig = dbCreateRect(layout list(36 -1) list(1.63:1.065 1.68:3.055))
mstr = dbOpenCellViewByType( pdkLib "cut_M1M4_1x2" "layout")
layInst=dbCreateInst(layout mstr "" 2.03:0.665 "R0")
fig = dbCreateRect(layout list(36 -1) list(2.03:0.0 2.08:0.595))
fig = dbCreateRect(layout list(36 -1) list(2.03:1.065 2.08:3.055))
mstr = dbOpenCellViewByType( pdkLib "cut_M1M4_1x2" "layout")
layInst=dbCreateInst(layout mstr "" 5.63:0.665 "R0")
fig = dbCreateRect(layout list(36 -1) list(5.63:0.0 5.68:0.595))
fig = dbCreateRect(layout list(36 -1) list(5.63:1.065 5.68:3.055))
mstr = dbOpenCellViewByType( pdkLib "cut_M1M4_1x2" "layout")
layInst=dbCreateInst(layout mstr "" 6.03:0.665 "R0")
fig = dbCreateRect(layout list(36 -1) list(6.03:0.0 6.08:0.595))
fig = dbCreateRect(layout list(36 -1) list(6.03:1.065 6.08:3.055))
mstr = dbOpenCellViewByType( pdkLib "cut_M1M4_1x2" "layout")
layInst=dbCreateInst(layout mstr "" 6.43:0.665 "R0")
fig = dbCreateRect(layout list(36 -1) list(6.43:0.0 6.48:0.595))
fig = dbCreateRect(layout list(36 -1) list(6.43:1.065 6.48:3.055))
mstr = dbOpenCellViewByType( pdkLib "cut_M1M4_1x2" "layout")
layInst=dbCreateInst(layout mstr "" 6.83:0.665 "R0")
fig = dbCreateRect(layout list(36 -1) list(6.83:0.0 6.88:0.595))
fig = dbCreateRect(layout list(36 -1) list(6.83:1.065 6.88:3.055))
mstr = dbOpenCellViewByType( pdkLib "cut_M1M4_1x2" "layout")
layInst=dbCreateInst(layout mstr "" 7.23:0.665 "R0")
fig = dbCreateRect(layout list(36 -1) list(7.23:0.0 7.28:0.595))
fig = dbCreateRect(layout list(36 -1) list(7.23:1.065 7.28:3.055))
mstr = dbOpenCellViewByType( pdkLib "cut_M1M4_1x2" "layout")
layInst=dbCreateInst(layout mstr "" 7.63:0.665 "R0")
fig = dbCreateRect(layout list(36 -1) list(7.63:0.0 7.68:0.595))
fig = dbCreateRect(layout list(36 -1) list(7.63:1.065 7.68:3.055))
mstr = dbOpenCellViewByType( pdkLib "cut_M1M4_1x2" "layout")
layInst=dbCreateInst(layout mstr "" 8.03:0.665 "R0")
fig = dbCreateRect(layout list(36 -1) list(8.03:0.0 8.08:0.595))
fig = dbCreateRect(layout list(36 -1) list(8.03:1.065 8.08:3.055))
mstr = dbOpenCellViewByType( pdkLib "cut_M1M4_1x2" "layout")
layInst=dbCreateInst(layout mstr "" 8.43:0.665 "R0")
fig = dbCreateRect(layout list(36 -1) list(8.43:0.0 8.48:0.595))
fig = dbCreateRect(layout list(36 -1) list(8.43:1.065 8.48:3.055))
mstr = dbOpenCellViewByType( pdkLib "cut_M1M4_1x2" "layout")
layInst=dbCreateInst(layout mstr "" 12.03:0.665 "R0")
fig = dbCreateRect(layout list(36 -1) list(12.03:0.0 12.08:0.595))
fig = dbCreateRect(layout list(36 -1) list(12.03:1.065 12.08:3.055))
mstr = dbOpenCellViewByType( pdkLib "cut_M1M4_1x2" "layout")
layInst=dbCreateInst(layout mstr "" 12.43:0.665 "R0")
fig = dbCreateRect(layout list(36 -1) list(12.43:0.0 12.48:0.595))
fig = dbCreateRect(layout list(36 -1) list(12.43:1.065 12.48:3.055))
mstr = dbOpenCellViewByType( pdkLib "cut_M1M4_1x2" "layout")
layInst=dbCreateInst(layout mstr "" 12.83:0.665 "R0")
fig = dbCreateRect(layout list(36 -1) list(12.83:0.0 12.88:0.595))
fig = dbCreateRect(layout list(36 -1) list(12.83:1.065 12.88:3.055))
mstr = dbOpenCellViewByType( pdkLib "cut_M1M4_1x2" "layout")
layInst=dbCreateInst(layout mstr "" 13.23:0.665 "R0")
fig = dbCreateRect(layout list(36 -1) list(13.23:0.0 13.28:0.595))
fig = dbCreateRect(layout list(36 -1) list(13.23:1.065 13.28:3.055))
fig = dbCreateRect(layout list(46 -1) list(0.63:0.0 0.68:3.055))
fig = dbCreateRect(layout list(36 -1) list(0.63:0.0 0.68:3.005))
fig = dbCreateRect(layout list(46 -1) list(0.83:0.2 0.88:2.855))
fig = dbCreateRect(layout list(42 -1) list(0.83:0.2 0.88:2.855))
fig = dbCreateRect(layout list(46 -1) list(1.03:0.0 1.08:3.055))
fig = dbCreateRect(layout list(36 -1) list(1.03:0.0 1.08:3.005))
fig = dbCreateRect(layout list(46 -1) list(1.23:0.2 1.28:2.855))
fig = dbCreateRect(layout list(42 -1) list(1.23:0.2 1.28:2.855))
fig = dbCreateRect(layout list(46 -1) list(1.43:0.0 1.48:3.055))
fig = dbCreateRect(layout list(36 -1) list(1.43:0.0 1.48:3.005))
fig = dbCreateRect(layout list(46 -1) list(1.63:0.2 1.68:2.855))
fig = dbCreateRect(layout list(42 -1) list(1.63:0.2 1.68:2.855))
fig = dbCreateRect(layout list(46 -1) list(1.83:0.0 1.88:3.055))
fig = dbCreateRect(layout list(36 -1) list(1.83:0.0 1.88:3.005))
fig = dbCreateRect(layout list(46 -1) list(2.03:0.2 2.08:2.855))
fig = dbCreateRect(layout list(42 -1) list(2.03:0.2 2.08:2.855))
fig = dbCreateRect(layout list(46 -1) list(2.23:0.0 2.28:3.055))
fig = dbCreateRect(layout list(36 -1) list(2.23:0.0 2.28:3.005))
fig = dbCreateRect(layout list(46 -1) list(2.43:0.2 2.48:2.855))
fig = dbCreateRect(layout list(42 -1) list(2.43:0.2 2.48:2.855))
fig = dbCreateRect(layout list(46 -1) list(2.63:0.0 2.68:3.055))
fig = dbCreateRect(layout list(36 -1) list(2.63:0.0 2.68:3.005))
fig = dbCreateRect(layout list(46 -1) list(2.83:0.2 2.88:2.855))
fig = dbCreateRect(layout list(42 -1) list(2.83:0.2 2.88:2.855))
fig = dbCreateRect(layout list(46 -1) list(3.03:0.0 3.08:3.055))
fig = dbCreateRect(layout list(36 -1) list(3.03:0.0 3.08:3.005))
fig = dbCreateRect(layout list(46 -1) list(3.23:0.2 3.28:2.855))
fig = dbCreateRect(layout list(42 -1) list(3.23:0.2 3.28:2.855))
fig = dbCreateRect(layout list(46 -1) list(3.43:0.0 3.48:3.055))
fig = dbCreateRect(layout list(36 -1) list(3.43:0.0 3.48:3.005))
fig = dbCreateRect(layout list(46 -1) list(3.63:0.2 3.68:2.855))
fig = dbCreateRect(layout list(42 -1) list(3.63:0.2 3.68:2.855))
fig = dbCreateRect(layout list(46 -1) list(3.83:0.0 3.88:3.055))
fig = dbCreateRect(layout list(36 -1) list(3.83:0.0 3.88:3.005))
fig = dbCreateRect(layout list(46 -1) list(4.03:0.2 4.08:2.855))
fig = dbCreateRect(layout list(42 -1) list(4.03:0.2 4.08:2.855))
fig = dbCreateRect(layout list(46 -1) list(4.23:0.0 4.28:3.055))
fig = dbCreateRect(layout list(36 -1) list(4.23:0.0 4.28:3.005))
fig = dbCreateRect(layout list(46 -1) list(4.43:0.2 4.48:2.855))
fig = dbCreateRect(layout list(42 -1) list(4.43:0.2 4.48:2.855))
fig = dbCreateRect(layout list(46 -1) list(4.63:0.0 4.68:3.055))
fig = dbCreateRect(layout list(36 -1) list(4.63:0.0 4.68:3.005))
fig = dbCreateRect(layout list(46 -1) list(4.83:0.2 4.88:2.855))
fig = dbCreateRect(layout list(42 -1) list(4.83:0.2 4.88:2.855))
fig = dbCreateRect(layout list(46 -1) list(5.03:0.0 5.08:3.055))
fig = dbCreateRect(layout list(36 -1) list(5.03:0.0 5.08:3.005))
fig = dbCreateRect(layout list(46 -1) list(5.23:0.2 5.28:2.855))
fig = dbCreateRect(layout list(42 -1) list(5.23:0.2 5.28:2.855))
fig = dbCreateRect(layout list(46 -1) list(5.43:0.0 5.48:3.055))
fig = dbCreateRect(layout list(36 -1) list(5.43:0.0 5.48:3.005))
fig = dbCreateRect(layout list(46 -1) list(5.63:0.2 5.68:2.855))
fig = dbCreateRect(layout list(42 -1) list(5.63:0.2 5.68:2.855))
fig = dbCreateRect(layout list(46 -1) list(5.83:0.0 5.88:3.055))
fig = dbCreateRect(layout list(36 -1) list(5.83:0.0 5.88:3.005))
fig = dbCreateRect(layout list(46 -1) list(6.03:0.2 6.08:2.855))
fig = dbCreateRect(layout list(42 -1) list(6.03:0.2 6.08:2.855))
fig = dbCreateRect(layout list(46 -1) list(6.23:0.0 6.28:3.055))
fig = dbCreateRect(layout list(36 -1) list(6.23:0.0 6.28:3.005))
fig = dbCreateRect(layout list(46 -1) list(6.43:0.2 6.48:2.855))
fig = dbCreateRect(layout list(42 -1) list(6.43:0.2 6.48:2.855))
fig = dbCreateRect(layout list(46 -1) list(6.63:0.0 6.68:3.055))
fig = dbCreateRect(layout list(36 -1) list(6.63:0.0 6.68:3.005))
fig = dbCreateRect(layout list(46 -1) list(6.83:0.2 6.88:2.855))
fig = dbCreateRect(layout list(42 -1) list(6.83:0.2 6.88:2.855))
fig = dbCreateRect(layout list(46 -1) list(7.03:0.0 7.08:3.055))
fig = dbCreateRect(layout list(36 -1) list(7.03:0.0 7.08:3.005))
fig = dbCreateRect(layout list(46 -1) list(7.23:0.2 7.28:2.855))
fig = dbCreateRect(layout list(42 -1) list(7.23:0.2 7.28:2.855))
fig = dbCreateRect(layout list(46 -1) list(7.43:0.0 7.48:3.055))
fig = dbCreateRect(layout list(36 -1) list(7.43:0.0 7.48:3.005))
fig = dbCreateRect(layout list(46 -1) list(7.63:0.2 7.68:2.855))
fig = dbCreateRect(layout list(42 -1) list(7.63:0.2 7.68:2.855))
fig = dbCreateRect(layout list(46 -1) list(7.83:0.0 7.88:3.055))
fig = dbCreateRect(layout list(36 -1) list(7.83:0.0 7.88:3.005))
fig = dbCreateRect(layout list(46 -1) list(8.03:0.2 8.08:2.855))
fig = dbCreateRect(layout list(42 -1) list(8.03:0.2 8.08:2.855))
fig = dbCreateRect(layout list(46 -1) list(8.23:0.0 8.28:3.055))
fig = dbCreateRect(layout list(36 -1) list(8.23:0.0 8.28:3.005))
fig = dbCreateRect(layout list(46 -1) list(8.43:0.2 8.48:2.855))
fig = dbCreateRect(layout list(42 -1) list(8.43:0.2 8.48:2.855))
fig = dbCreateRect(layout list(46 -1) list(8.63:0.0 8.68:3.055))
fig = dbCreateRect(layout list(36 -1) list(8.63:0.0 8.68:3.005))
fig = dbCreateRect(layout list(46 -1) list(8.83:0.2 8.88:2.855))
fig = dbCreateRect(layout list(42 -1) list(8.83:0.2 8.88:2.855))
fig = dbCreateRect(layout list(46 -1) list(9.03:0.0 9.08:3.055))
fig = dbCreateRect(layout list(36 -1) list(9.03:0.0 9.08:3.005))
fig = dbCreateRect(layout list(46 -1) list(9.23:0.2 9.28:2.855))
fig = dbCreateRect(layout list(42 -1) list(9.23:0.2 9.28:2.855))
fig = dbCreateRect(layout list(46 -1) list(9.43:0.0 9.48:3.055))
fig = dbCreateRect(layout list(36 -1) list(9.43:0.0 9.48:3.005))
fig = dbCreateRect(layout list(46 -1) list(9.63:0.2 9.68:2.855))
fig = dbCreateRect(layout list(42 -1) list(9.63:0.2 9.68:2.855))
fig = dbCreateRect(layout list(46 -1) list(9.83:0.0 9.88:3.055))
fig = dbCreateRect(layout list(36 -1) list(9.83:0.0 9.88:3.005))
fig = dbCreateRect(layout list(46 -1) list(10.03:0.2 10.08:2.855))
fig = dbCreateRect(layout list(42 -1) list(10.03:0.2 10.08:2.855))
fig = dbCreateRect(layout list(46 -1) list(10.23:0.0 10.28:3.055))
fig = dbCreateRect(layout list(36 -1) list(10.23:0.0 10.28:3.005))
fig = dbCreateRect(layout list(46 -1) list(10.43:0.2 10.48:2.855))
fig = dbCreateRect(layout list(42 -1) list(10.43:0.2 10.48:2.855))
fig = dbCreateRect(layout list(46 -1) list(10.63:0.0 10.68:3.055))
fig = dbCreateRect(layout list(36 -1) list(10.63:0.0 10.68:3.005))
fig = dbCreateRect(layout list(46 -1) list(10.83:0.2 10.88:2.855))
fig = dbCreateRect(layout list(42 -1) list(10.83:0.2 10.88:2.855))
fig = dbCreateRect(layout list(46 -1) list(11.03:0.0 11.08:3.055))
fig = dbCreateRect(layout list(36 -1) list(11.03:0.0 11.08:3.005))
fig = dbCreateRect(layout list(46 -1) list(11.23:0.2 11.28:2.855))
fig = dbCreateRect(layout list(42 -1) list(11.23:0.2 11.28:2.855))
fig = dbCreateRect(layout list(46 -1) list(11.43:0.0 11.48:3.055))
fig = dbCreateRect(layout list(36 -1) list(11.43:0.0 11.48:3.005))
fig = dbCreateRect(layout list(46 -1) list(11.63:0.2 11.68:2.855))
fig = dbCreateRect(layout list(42 -1) list(11.63:0.2 11.68:2.855))
fig = dbCreateRect(layout list(46 -1) list(11.83:0.0 11.88:3.055))
fig = dbCreateRect(layout list(36 -1) list(11.83:0.0 11.88:3.005))
fig = dbCreateRect(layout list(46 -1) list(12.03:0.2 12.08:2.855))
fig = dbCreateRect(layout list(42 -1) list(12.03:0.2 12.08:2.855))
fig = dbCreateRect(layout list(46 -1) list(12.23:0.0 12.28:3.055))
fig = dbCreateRect(layout list(36 -1) list(12.23:0.0 12.28:3.005))
fig = dbCreateRect(layout list(46 -1) list(12.43:0.2 12.48:2.855))
fig = dbCreateRect(layout list(42 -1) list(12.43:0.2 12.48:2.855))
fig = dbCreateRect(layout list(46 -1) list(12.63:0.0 12.68:3.055))
fig = dbCreateRect(layout list(36 -1) list(12.63:0.0 12.68:3.005))
fig = dbCreateRect(layout list(46 -1) list(12.83:0.2 12.88:2.855))
fig = dbCreateRect(layout list(42 -1) list(12.83:0.2 12.88:2.855))
fig = dbCreateRect(layout list(46 -1) list(13.03:0.0 13.08:3.055))
fig = dbCreateRect(layout list(36 -1) list(13.03:0.0 13.08:3.005))
fig = dbCreateRect(layout list(46 -1) list(13.23:0.2 13.28:2.855))
fig = dbCreateRect(layout list(42 -1) list(13.23:0.2 13.28:2.855))
fig = dbCreateRect(layout list(36 -1) list(13.63:0.0 13.68:3.055))
fig = dbCreateRect(layout list(42 -1) list(13.63:0.0 13.68:3.055))
fig = dbCreateRect(layout list(46 -1) list(13.63:0.0 13.68:3.055))
fig = dbCreateRect(layout list(46 -1) list(13.43:0.0 13.48:3.055))
fig = dbCreateRect(layout list(36 -1) list(13.43:0.0 13.48:3.055))
fig = dbCreateRect(layout list(34 -1) list(0.45:0.805 13.43:0.855))
fig = dbCreateRect(layout list(34 -1) list(0.45:0.34 13.43:0.39))
fig = dbCreateRect(layout list(34 -1) list(0.45:2.665 13.43:2.715))
fig = dbCreateRect(layout list(34 -1) list(0.45:1.27 13.43:1.32))
fig = dbCreateRect(layout list(34 -1) list(0.45:2.2 13.43:2.25))
fig = dbCreateRect(layout list(34 -1) list(0.45:1.735 13.43:1.785))
fig = dbCreateRect(layout list(36 -1) list(0.63:0.0 13.63:0.05))
fig = dbCreateRect(layout list(36 -1) list(0.63:3.005 13.63:3.055))
fig = dbCreateRect(layout list(46 -1) list(0.63:0.0 13.43:0.05))
fig = dbCreateRect(layout list(46 -1) list(0.63:3.005 13.43:3.055))
 dbSave(layout) )
