schLibName = "SAR9B"
    techLib = "tech"
    inputPinMaster=dbOpenCellView("basic" "ipin" "symbol" nil "r")
    outputPinMaster=dbOpenCellView("basic" "opin" "symbol" nil "r")
    inputOutputPinMaster=dbOpenCellView("basic" "iopin" "symbol" nil "r")

;Create cell
sch = dbOpenCellViewByType(schLibName "CDAC9_CV" "schematic" "schematic" "w")
schName = "CDAC9_CV"
xcoord = 1
ycoord = 0

myCP_13_ = schCreatePin( sch inputOutputPinMaster "CP<13>" "inputOutput" nil 0:0 "R0" )
myTermCP_13_ = (setof pin sch->terminals (pcreMatchp "CP<13>" pin->name))
myprebBoxCP_13_ = car(car(myCP_13_~>master~>terminals~>pins)~>fig~>bBox)
mybBoxCP_13_ = dbTransformBBox(myprebBoxCP_13_ myCP_13_~>transform)

myCP_12_ = schCreatePin( sch inputOutputPinMaster "CP<12>" "inputOutput" nil 0:0.2 "R0" )
myTermCP_12_ = (setof pin sch->terminals (pcreMatchp "CP<12>" pin->name))
myprebBoxCP_12_ = car(car(myCP_12_~>master~>terminals~>pins)~>fig~>bBox)
mybBoxCP_12_ = dbTransformBBox(myprebBoxCP_12_ myCP_12_~>transform)

myCP_11_ = schCreatePin( sch inputOutputPinMaster "CP<11>" "inputOutput" nil 0:0.4 "R0" )
myTermCP_11_ = (setof pin sch->terminals (pcreMatchp "CP<11>" pin->name))
myprebBoxCP_11_ = car(car(myCP_11_~>master~>terminals~>pins)~>fig~>bBox)
mybBoxCP_11_ = dbTransformBBox(myprebBoxCP_11_ myCP_11_~>transform)

myCP_10_ = schCreatePin( sch inputOutputPinMaster "CP<10>" "inputOutput" nil 0:0.6000000000000001 "R0" )
myTermCP_10_ = (setof pin sch->terminals (pcreMatchp "CP<10>" pin->name))
myprebBoxCP_10_ = car(car(myCP_10_~>master~>terminals~>pins)~>fig~>bBox)
mybBoxCP_10_ = dbTransformBBox(myprebBoxCP_10_ myCP_10_~>transform)

myCP_9_ = schCreatePin( sch inputOutputPinMaster "CP<9>" "inputOutput" nil 0:0.8 "R0" )
myTermCP_9_ = (setof pin sch->terminals (pcreMatchp "CP<9>" pin->name))
myprebBoxCP_9_ = car(car(myCP_9_~>master~>terminals~>pins)~>fig~>bBox)
mybBoxCP_9_ = dbTransformBBox(myprebBoxCP_9_ myCP_9_~>transform)

myCP_8_ = schCreatePin( sch inputOutputPinMaster "CP<8>" "inputOutput" nil 0:1.0 "R0" )
myTermCP_8_ = (setof pin sch->terminals (pcreMatchp "CP<8>" pin->name))
myprebBoxCP_8_ = car(car(myCP_8_~>master~>terminals~>pins)~>fig~>bBox)
mybBoxCP_8_ = dbTransformBBox(myprebBoxCP_8_ myCP_8_~>transform)

myCP_7_ = schCreatePin( sch inputOutputPinMaster "CP<7>" "inputOutput" nil 0:1.2 "R0" )
myTermCP_7_ = (setof pin sch->terminals (pcreMatchp "CP<7>" pin->name))
myprebBoxCP_7_ = car(car(myCP_7_~>master~>terminals~>pins)~>fig~>bBox)
mybBoxCP_7_ = dbTransformBBox(myprebBoxCP_7_ myCP_7_~>transform)

myCP_6_ = schCreatePin( sch inputOutputPinMaster "CP<6>" "inputOutput" nil 0:1.4 "R0" )
myTermCP_6_ = (setof pin sch->terminals (pcreMatchp "CP<6>" pin->name))
myprebBoxCP_6_ = car(car(myCP_6_~>master~>terminals~>pins)~>fig~>bBox)
mybBoxCP_6_ = dbTransformBBox(myprebBoxCP_6_ myCP_6_~>transform)

myCP_5_ = schCreatePin( sch inputOutputPinMaster "CP<5>" "inputOutput" nil 0:1.5999999999999999 "R0" )
myTermCP_5_ = (setof pin sch->terminals (pcreMatchp "CP<5>" pin->name))
myprebBoxCP_5_ = car(car(myCP_5_~>master~>terminals~>pins)~>fig~>bBox)
mybBoxCP_5_ = dbTransformBBox(myprebBoxCP_5_ myCP_5_~>transform)

myCP_4_ = schCreatePin( sch inputOutputPinMaster "CP<4>" "inputOutput" nil 0:1.7999999999999998 "R0" )
myTermCP_4_ = (setof pin sch->terminals (pcreMatchp "CP<4>" pin->name))
myprebBoxCP_4_ = car(car(myCP_4_~>master~>terminals~>pins)~>fig~>bBox)
mybBoxCP_4_ = dbTransformBBox(myprebBoxCP_4_ myCP_4_~>transform)

myCP_3_ = schCreatePin( sch inputOutputPinMaster "CP<3>" "inputOutput" nil 0:1.9999999999999998 "R0" )
myTermCP_3_ = (setof pin sch->terminals (pcreMatchp "CP<3>" pin->name))
myprebBoxCP_3_ = car(car(myCP_3_~>master~>terminals~>pins)~>fig~>bBox)
mybBoxCP_3_ = dbTransformBBox(myprebBoxCP_3_ myCP_3_~>transform)

myCP_2_ = schCreatePin( sch inputOutputPinMaster "CP<2>" "inputOutput" nil 0:2.1999999999999997 "R0" )
myTermCP_2_ = (setof pin sch->terminals (pcreMatchp "CP<2>" pin->name))
myprebBoxCP_2_ = car(car(myCP_2_~>master~>terminals~>pins)~>fig~>bBox)
mybBoxCP_2_ = dbTransformBBox(myprebBoxCP_2_ myCP_2_~>transform)

myCP_1_ = schCreatePin( sch inputOutputPinMaster "CP<1>" "inputOutput" nil 0:2.4 "R0" )
myTermCP_1_ = (setof pin sch->terminals (pcreMatchp "CP<1>" pin->name))
myprebBoxCP_1_ = car(car(myCP_1_~>master~>terminals~>pins)~>fig~>bBox)
mybBoxCP_1_ = dbTransformBBox(myprebBoxCP_1_ myCP_1_~>transform)

myCP_0_ = schCreatePin( sch inputOutputPinMaster "CP<0>" "inputOutput" nil 0:2.6 "R0" )
myTermCP_0_ = (setof pin sch->terminals (pcreMatchp "CP<0>" pin->name))
myprebBoxCP_0_ = car(car(myCP_0_~>master~>terminals~>pins)~>fig~>bBox)
mybBoxCP_0_ = dbTransformBBox(myprebBoxCP_0_ myCP_0_~>transform)

myCTOP = schCreatePin( sch inputOutputPinMaster "CTOP" "inputOutput" nil 0:2.8000000000000003 "R0" )
myTermCTOP = (setof pin sch->terminals (pcreMatchp "CTOP" pin->name))
myprebBoxCTOP = car(car(myCTOP~>master~>terminals~>pins)~>fig~>bBox)
mybBoxCTOP = dbTransformBBox(myprebBoxCTOP myCTOP~>transform)

myAVSS = schCreatePin( sch inputOutputPinMaster "AVSS" "inputOutput" nil 0:3.0000000000000004 "R0" )
myTermAVSS = (setof pin sch->terminals (pcreMatchp "AVSS" pin->name))
myprebBoxAVSS = car(car(myAVSS~>master~>terminals~>pins)~>fig~>bBox)
mybBoxAVSS = dbTransformBBox(myprebBoxAVSS myAVSS~>transform)

        syb =  ddGetObj("cpdk" "CDAC9" "symbol")
        if( syb then
          syb_dd = dbOpenCellViewByType("cpdk" "CDAC9" "symbol")
          dbCopyCellView(syb_dd schLibName schName "symbol" ?g_overwrite t)
        )

unless( ddGetObj(schLibName schName "symbol")
        schViewToView( schLibName schName schLibName schName "schematic" "symbol" "schSchemToPinList" "schPinListToSymbol" )
)

    ;;-------------------------------------------------------------------
    ;; Create instance XC1
    ;;-------------------------------------------------------------------
        schLib = dbOpenCellViewByType("SAR9B" "CAP32C_CV" "symbol")
        schInst=dbCreateInst(sch schLib "XC1" xcoord:ycoord "R180")
        xcoord = xcoord  + rightEdge(schLib->bBox) - leftEdge(schLib->bBox) + 1
        if(xcoord > 15 then
                    xcoord = 2
                    ycoord = ycoord +  topEdge(schLib->bBox) - bottomEdge(schLib->bBox) + 1
        )

            signal = (setof sig schLib~>signals (member "C1A" sig~>sigNames))
            bBox = car(car(signal~>pins)~>fig)~>bBox
            pin =dbTransformBBox(bBox schInst~>transform)

            wireId = schCreateWire( sch "draw" "full" list(centerBox(pin) rodAddToX(centerBox(pin) 0.05) )  0.0625 0.0625 0.0 )
            schCreateWireLabel( sch car(wireId) rodAddToX(centerBox(pin) 0.125)  "CP<12>" "lowerLeft" "R0" "stick" 0.0625 nil )

            signal = (setof sig schLib~>signals (member "C1B" sig~>sigNames))
            bBox = car(car(signal~>pins)~>fig)~>bBox
            pin =dbTransformBBox(bBox schInst~>transform)

            wireId = schCreateWire( sch "draw" "full" list(centerBox(pin) rodAddToX(centerBox(pin) 0.05) )  0.0625 0.0625 0.0 )
            schCreateWireLabel( sch car(wireId) rodAddToX(centerBox(pin) 0.125)  "CP<12>" "lowerLeft" "R0" "stick" 0.0625 nil )

            signal = (setof sig schLib~>signals (member "C2" sig~>sigNames))
            bBox = car(car(signal~>pins)~>fig)~>bBox
            pin =dbTransformBBox(bBox schInst~>transform)

            wireId = schCreateWire( sch "draw" "full" list(centerBox(pin) rodAddToX(centerBox(pin) 0.05) )  0.0625 0.0625 0.0 )
            schCreateWireLabel( sch car(wireId) rodAddToX(centerBox(pin) 0.125)  "CP<12>" "lowerLeft" "R0" "stick" 0.0625 nil )

            signal = (setof sig schLib~>signals (member "C4" sig~>sigNames))
            bBox = car(car(signal~>pins)~>fig)~>bBox
            pin =dbTransformBBox(bBox schInst~>transform)

            wireId = schCreateWire( sch "draw" "full" list(centerBox(pin) rodAddToX(centerBox(pin) 0.05) )  0.0625 0.0625 0.0 )
            schCreateWireLabel( sch car(wireId) rodAddToX(centerBox(pin) 0.125)  "CP<12>" "lowerLeft" "R0" "stick" 0.0625 nil )

            signal = (setof sig schLib~>signals (member "C8" sig~>sigNames))
            bBox = car(car(signal~>pins)~>fig)~>bBox
            pin =dbTransformBBox(bBox schInst~>transform)

            wireId = schCreateWire( sch "draw" "full" list(centerBox(pin) rodAddToX(centerBox(pin) 0.05) )  0.0625 0.0625 0.0 )
            schCreateWireLabel( sch car(wireId) rodAddToX(centerBox(pin) 0.125)  "CP<12>" "lowerLeft" "R0" "stick" 0.0625 nil )

            signal = (setof sig schLib~>signals (member "C16" sig~>sigNames))
            bBox = car(car(signal~>pins)~>fig)~>bBox
            pin =dbTransformBBox(bBox schInst~>transform)

            wireId = schCreateWire( sch "draw" "full" list(centerBox(pin) rodAddToX(centerBox(pin) 0.05) )  0.0625 0.0625 0.0 )
            schCreateWireLabel( sch car(wireId) rodAddToX(centerBox(pin) 0.125)  "CP<12>" "lowerLeft" "R0" "stick" 0.0625 nil )

            signal = (setof sig schLib~>signals (member "CTOP" sig~>sigNames))
            bBox = car(car(signal~>pins)~>fig)~>bBox
            pin =dbTransformBBox(bBox schInst~>transform)

            wireId = schCreateWire( sch "draw" "full" list(centerBox(pin) rodAddToX(centerBox(pin) 0.05) )  0.0625 0.0625 0.0 )
            schCreateWireLabel( sch car(wireId) rodAddToX(centerBox(pin) 0.125)  "CTOP" "lowerLeft" "R0" "stick" 0.0625 nil )

            signal = (setof sig schLib~>signals (member "AVSS" sig~>sigNames))
            bBox = car(car(signal~>pins)~>fig)~>bBox
            pin =dbTransformBBox(bBox schInst~>transform)

            wireId = schCreateWire( sch "draw" "full" list(centerBox(pin) rodAddToX(centerBox(pin) 0.05) )  0.0625 0.0625 0.0 )
            schCreateWireLabel( sch car(wireId) rodAddToX(centerBox(pin) 0.125)  "AVSS" "lowerLeft" "R0" "stick" 0.0625 nil )

    ;;-------------------------------------------------------------------
    ;; Create instance XC256a<7>
    ;;-------------------------------------------------------------------
        schLib = dbOpenCellViewByType("SAR9B" "CAP32C_CV" "symbol")
        schInst=dbCreateInst(sch schLib "XC256a<7>" xcoord:ycoord "R180")
        xcoord = xcoord  + rightEdge(schLib->bBox) - leftEdge(schLib->bBox) + 1
        if(xcoord > 15 then
                    xcoord = 2
                    ycoord = ycoord +  topEdge(schLib->bBox) - bottomEdge(schLib->bBox) + 1
        )

            signal = (setof sig schLib~>signals (member "C1A" sig~>sigNames))
            bBox = car(car(signal~>pins)~>fig)~>bBox
            pin =dbTransformBBox(bBox schInst~>transform)

            wireId = schCreateWire( sch "draw" "full" list(centerBox(pin) rodAddToX(centerBox(pin) 0.05) )  0.0625 0.0625 0.0 )
            schCreateWireLabel( sch car(wireId) rodAddToX(centerBox(pin) 0.125)  "CP<13>" "lowerLeft" "R0" "stick" 0.0625 nil )

            signal = (setof sig schLib~>signals (member "C1B" sig~>sigNames))
            bBox = car(car(signal~>pins)~>fig)~>bBox
            pin =dbTransformBBox(bBox schInst~>transform)

            wireId = schCreateWire( sch "draw" "full" list(centerBox(pin) rodAddToX(centerBox(pin) 0.05) )  0.0625 0.0625 0.0 )
            schCreateWireLabel( sch car(wireId) rodAddToX(centerBox(pin) 0.125)  "CP<13>" "lowerLeft" "R0" "stick" 0.0625 nil )

            signal = (setof sig schLib~>signals (member "C2" sig~>sigNames))
            bBox = car(car(signal~>pins)~>fig)~>bBox
            pin =dbTransformBBox(bBox schInst~>transform)

            wireId = schCreateWire( sch "draw" "full" list(centerBox(pin) rodAddToX(centerBox(pin) 0.05) )  0.0625 0.0625 0.0 )
            schCreateWireLabel( sch car(wireId) rodAddToX(centerBox(pin) 0.125)  "CP<13>" "lowerLeft" "R0" "stick" 0.0625 nil )

            signal = (setof sig schLib~>signals (member "C4" sig~>sigNames))
            bBox = car(car(signal~>pins)~>fig)~>bBox
            pin =dbTransformBBox(bBox schInst~>transform)

            wireId = schCreateWire( sch "draw" "full" list(centerBox(pin) rodAddToX(centerBox(pin) 0.05) )  0.0625 0.0625 0.0 )
            schCreateWireLabel( sch car(wireId) rodAddToX(centerBox(pin) 0.125)  "CP<13>" "lowerLeft" "R0" "stick" 0.0625 nil )

            signal = (setof sig schLib~>signals (member "C8" sig~>sigNames))
            bBox = car(car(signal~>pins)~>fig)~>bBox
            pin =dbTransformBBox(bBox schInst~>transform)

            wireId = schCreateWire( sch "draw" "full" list(centerBox(pin) rodAddToX(centerBox(pin) 0.05) )  0.0625 0.0625 0.0 )
            schCreateWireLabel( sch car(wireId) rodAddToX(centerBox(pin) 0.125)  "CP<13>" "lowerLeft" "R0" "stick" 0.0625 nil )

            signal = (setof sig schLib~>signals (member "C16" sig~>sigNames))
            bBox = car(car(signal~>pins)~>fig)~>bBox
            pin =dbTransformBBox(bBox schInst~>transform)

            wireId = schCreateWire( sch "draw" "full" list(centerBox(pin) rodAddToX(centerBox(pin) 0.05) )  0.0625 0.0625 0.0 )
            schCreateWireLabel( sch car(wireId) rodAddToX(centerBox(pin) 0.125)  "CP<13>" "lowerLeft" "R0" "stick" 0.0625 nil )

            signal = (setof sig schLib~>signals (member "CTOP" sig~>sigNames))
            bBox = car(car(signal~>pins)~>fig)~>bBox
            pin =dbTransformBBox(bBox schInst~>transform)

            wireId = schCreateWire( sch "draw" "full" list(centerBox(pin) rodAddToX(centerBox(pin) 0.05) )  0.0625 0.0625 0.0 )
            schCreateWireLabel( sch car(wireId) rodAddToX(centerBox(pin) 0.125)  "CTOP" "lowerLeft" "R0" "stick" 0.0625 nil )

            signal = (setof sig schLib~>signals (member "AVSS" sig~>sigNames))
            bBox = car(car(signal~>pins)~>fig)~>bBox
            pin =dbTransformBBox(bBox schInst~>transform)

            wireId = schCreateWire( sch "draw" "full" list(centerBox(pin) rodAddToX(centerBox(pin) 0.05) )  0.0625 0.0625 0.0 )
            schCreateWireLabel( sch car(wireId) rodAddToX(centerBox(pin) 0.125)  "AVSS" "lowerLeft" "R0" "stick" 0.0625 nil )

    ;;-------------------------------------------------------------------
    ;; Create instance XC128b<3>
    ;;-------------------------------------------------------------------
        schLib = dbOpenCellViewByType("SAR9B" "CAP32C_CV" "symbol")
        schInst=dbCreateInst(sch schLib "XC128b<3>" xcoord:ycoord "R180")
        xcoord = xcoord  + rightEdge(schLib->bBox) - leftEdge(schLib->bBox) + 1
        if(xcoord > 15 then
                    xcoord = 2
                    ycoord = ycoord +  topEdge(schLib->bBox) - bottomEdge(schLib->bBox) + 1
        )

            signal = (setof sig schLib~>signals (member "C1A" sig~>sigNames))
            bBox = car(car(signal~>pins)~>fig)~>bBox
            pin =dbTransformBBox(bBox schInst~>transform)

            wireId = schCreateWire( sch "draw" "full" list(centerBox(pin) rodAddToX(centerBox(pin) 0.05) )  0.0625 0.0625 0.0 )
            schCreateWireLabel( sch car(wireId) rodAddToX(centerBox(pin) 0.125)  "CP<10>" "lowerLeft" "R0" "stick" 0.0625 nil )

            signal = (setof sig schLib~>signals (member "C1B" sig~>sigNames))
            bBox = car(car(signal~>pins)~>fig)~>bBox
            pin =dbTransformBBox(bBox schInst~>transform)

            wireId = schCreateWire( sch "draw" "full" list(centerBox(pin) rodAddToX(centerBox(pin) 0.05) )  0.0625 0.0625 0.0 )
            schCreateWireLabel( sch car(wireId) rodAddToX(centerBox(pin) 0.125)  "CP<10>" "lowerLeft" "R0" "stick" 0.0625 nil )

            signal = (setof sig schLib~>signals (member "C2" sig~>sigNames))
            bBox = car(car(signal~>pins)~>fig)~>bBox
            pin =dbTransformBBox(bBox schInst~>transform)

            wireId = schCreateWire( sch "draw" "full" list(centerBox(pin) rodAddToX(centerBox(pin) 0.05) )  0.0625 0.0625 0.0 )
            schCreateWireLabel( sch car(wireId) rodAddToX(centerBox(pin) 0.125)  "CP<10>" "lowerLeft" "R0" "stick" 0.0625 nil )

            signal = (setof sig schLib~>signals (member "C4" sig~>sigNames))
            bBox = car(car(signal~>pins)~>fig)~>bBox
            pin =dbTransformBBox(bBox schInst~>transform)

            wireId = schCreateWire( sch "draw" "full" list(centerBox(pin) rodAddToX(centerBox(pin) 0.05) )  0.0625 0.0625 0.0 )
            schCreateWireLabel( sch car(wireId) rodAddToX(centerBox(pin) 0.125)  "CP<10>" "lowerLeft" "R0" "stick" 0.0625 nil )

            signal = (setof sig schLib~>signals (member "C8" sig~>sigNames))
            bBox = car(car(signal~>pins)~>fig)~>bBox
            pin =dbTransformBBox(bBox schInst~>transform)

            wireId = schCreateWire( sch "draw" "full" list(centerBox(pin) rodAddToX(centerBox(pin) 0.05) )  0.0625 0.0625 0.0 )
            schCreateWireLabel( sch car(wireId) rodAddToX(centerBox(pin) 0.125)  "CP<10>" "lowerLeft" "R0" "stick" 0.0625 nil )

            signal = (setof sig schLib~>signals (member "C16" sig~>sigNames))
            bBox = car(car(signal~>pins)~>fig)~>bBox
            pin =dbTransformBBox(bBox schInst~>transform)

            wireId = schCreateWire( sch "draw" "full" list(centerBox(pin) rodAddToX(centerBox(pin) 0.05) )  0.0625 0.0625 0.0 )
            schCreateWireLabel( sch car(wireId) rodAddToX(centerBox(pin) 0.125)  "CP<10>" "lowerLeft" "R0" "stick" 0.0625 nil )

            signal = (setof sig schLib~>signals (member "CTOP" sig~>sigNames))
            bBox = car(car(signal~>pins)~>fig)~>bBox
            pin =dbTransformBBox(bBox schInst~>transform)

            wireId = schCreateWire( sch "draw" "full" list(centerBox(pin) rodAddToX(centerBox(pin) 0.05) )  0.0625 0.0625 0.0 )
            schCreateWireLabel( sch car(wireId) rodAddToX(centerBox(pin) 0.125)  "CTOP" "lowerLeft" "R0" "stick" 0.0625 nil )

            signal = (setof sig schLib~>signals (member "AVSS" sig~>sigNames))
            bBox = car(car(signal~>pins)~>fig)~>bBox
            pin =dbTransformBBox(bBox schInst~>transform)

            wireId = schCreateWire( sch "draw" "full" list(centerBox(pin) rodAddToX(centerBox(pin) 0.05) )  0.0625 0.0625 0.0 )
            schCreateWireLabel( sch car(wireId) rodAddToX(centerBox(pin) 0.125)  "AVSS" "lowerLeft" "R0" "stick" 0.0625 nil )

    ;;-------------------------------------------------------------------
    ;; Create instance XC64a<0>
    ;;-------------------------------------------------------------------
        schLib = dbOpenCellViewByType("SAR9B" "CAP32C_CV" "symbol")
        schInst=dbCreateInst(sch schLib "XC64a<0>" xcoord:ycoord "R180")
        xcoord = xcoord  + rightEdge(schLib->bBox) - leftEdge(schLib->bBox) + 1
        if(xcoord > 15 then
                    xcoord = 2
                    ycoord = ycoord +  topEdge(schLib->bBox) - bottomEdge(schLib->bBox) + 1
        )

            signal = (setof sig schLib~>signals (member "C1A" sig~>sigNames))
            bBox = car(car(signal~>pins)~>fig)~>bBox
            pin =dbTransformBBox(bBox schInst~>transform)

            wireId = schCreateWire( sch "draw" "full" list(centerBox(pin) rodAddToX(centerBox(pin) 0.05) )  0.0625 0.0625 0.0 )
            schCreateWireLabel( sch car(wireId) rodAddToX(centerBox(pin) 0.125)  "CP<8>" "lowerLeft" "R0" "stick" 0.0625 nil )

            signal = (setof sig schLib~>signals (member "C1B" sig~>sigNames))
            bBox = car(car(signal~>pins)~>fig)~>bBox
            pin =dbTransformBBox(bBox schInst~>transform)

            wireId = schCreateWire( sch "draw" "full" list(centerBox(pin) rodAddToX(centerBox(pin) 0.05) )  0.0625 0.0625 0.0 )
            schCreateWireLabel( sch car(wireId) rodAddToX(centerBox(pin) 0.125)  "CP<8>" "lowerLeft" "R0" "stick" 0.0625 nil )

            signal = (setof sig schLib~>signals (member "C2" sig~>sigNames))
            bBox = car(car(signal~>pins)~>fig)~>bBox
            pin =dbTransformBBox(bBox schInst~>transform)

            wireId = schCreateWire( sch "draw" "full" list(centerBox(pin) rodAddToX(centerBox(pin) 0.05) )  0.0625 0.0625 0.0 )
            schCreateWireLabel( sch car(wireId) rodAddToX(centerBox(pin) 0.125)  "CP<8>" "lowerLeft" "R0" "stick" 0.0625 nil )

            signal = (setof sig schLib~>signals (member "C4" sig~>sigNames))
            bBox = car(car(signal~>pins)~>fig)~>bBox
            pin =dbTransformBBox(bBox schInst~>transform)

            wireId = schCreateWire( sch "draw" "full" list(centerBox(pin) rodAddToX(centerBox(pin) 0.05) )  0.0625 0.0625 0.0 )
            schCreateWireLabel( sch car(wireId) rodAddToX(centerBox(pin) 0.125)  "CP<8>" "lowerLeft" "R0" "stick" 0.0625 nil )

            signal = (setof sig schLib~>signals (member "C8" sig~>sigNames))
            bBox = car(car(signal~>pins)~>fig)~>bBox
            pin =dbTransformBBox(bBox schInst~>transform)

            wireId = schCreateWire( sch "draw" "full" list(centerBox(pin) rodAddToX(centerBox(pin) 0.05) )  0.0625 0.0625 0.0 )
            schCreateWireLabel( sch car(wireId) rodAddToX(centerBox(pin) 0.125)  "CP<8>" "lowerLeft" "R0" "stick" 0.0625 nil )

            signal = (setof sig schLib~>signals (member "C16" sig~>sigNames))
            bBox = car(car(signal~>pins)~>fig)~>bBox
            pin =dbTransformBBox(bBox schInst~>transform)

            wireId = schCreateWire( sch "draw" "full" list(centerBox(pin) rodAddToX(centerBox(pin) 0.05) )  0.0625 0.0625 0.0 )
            schCreateWireLabel( sch car(wireId) rodAddToX(centerBox(pin) 0.125)  "CP<8>" "lowerLeft" "R0" "stick" 0.0625 nil )

            signal = (setof sig schLib~>signals (member "CTOP" sig~>sigNames))
            bBox = car(car(signal~>pins)~>fig)~>bBox
            pin =dbTransformBBox(bBox schInst~>transform)

            wireId = schCreateWire( sch "draw" "full" list(centerBox(pin) rodAddToX(centerBox(pin) 0.05) )  0.0625 0.0625 0.0 )
            schCreateWireLabel( sch car(wireId) rodAddToX(centerBox(pin) 0.125)  "CTOP" "lowerLeft" "R0" "stick" 0.0625 nil )

            signal = (setof sig schLib~>signals (member "AVSS" sig~>sigNames))
            bBox = car(car(signal~>pins)~>fig)~>bBox
            pin =dbTransformBBox(bBox schInst~>transform)

            wireId = schCreateWire( sch "draw" "full" list(centerBox(pin) rodAddToX(centerBox(pin) 0.05) )  0.0625 0.0625 0.0 )
            schCreateWireLabel( sch car(wireId) rodAddToX(centerBox(pin) 0.125)  "AVSS" "lowerLeft" "R0" "stick" 0.0625 nil )

    ;;-------------------------------------------------------------------
    ;; Create instance XC32a<0>
    ;;-------------------------------------------------------------------
        schLib = dbOpenCellViewByType("SAR9B" "CAP32C_CV" "symbol")
        schInst=dbCreateInst(sch schLib "XC32a<0>" xcoord:ycoord "R180")
        xcoord = xcoord  + rightEdge(schLib->bBox) - leftEdge(schLib->bBox) + 1
        if(xcoord > 15 then
                    xcoord = 2
                    ycoord = ycoord +  topEdge(schLib->bBox) - bottomEdge(schLib->bBox) + 1
        )

            signal = (setof sig schLib~>signals (member "C1A" sig~>sigNames))
            bBox = car(car(signal~>pins)~>fig)~>bBox
            pin =dbTransformBBox(bBox schInst~>transform)

            wireId = schCreateWire( sch "draw" "full" list(centerBox(pin) rodAddToX(centerBox(pin) 0.05) )  0.0625 0.0625 0.0 )
            schCreateWireLabel( sch car(wireId) rodAddToX(centerBox(pin) 0.125)  "CP<6>" "lowerLeft" "R0" "stick" 0.0625 nil )

            signal = (setof sig schLib~>signals (member "C1B" sig~>sigNames))
            bBox = car(car(signal~>pins)~>fig)~>bBox
            pin =dbTransformBBox(bBox schInst~>transform)

            wireId = schCreateWire( sch "draw" "full" list(centerBox(pin) rodAddToX(centerBox(pin) 0.05) )  0.0625 0.0625 0.0 )
            schCreateWireLabel( sch car(wireId) rodAddToX(centerBox(pin) 0.125)  "CP<6>" "lowerLeft" "R0" "stick" 0.0625 nil )

            signal = (setof sig schLib~>signals (member "C2" sig~>sigNames))
            bBox = car(car(signal~>pins)~>fig)~>bBox
            pin =dbTransformBBox(bBox schInst~>transform)

            wireId = schCreateWire( sch "draw" "full" list(centerBox(pin) rodAddToX(centerBox(pin) 0.05) )  0.0625 0.0625 0.0 )
            schCreateWireLabel( sch car(wireId) rodAddToX(centerBox(pin) 0.125)  "CP<6>" "lowerLeft" "R0" "stick" 0.0625 nil )

            signal = (setof sig schLib~>signals (member "C4" sig~>sigNames))
            bBox = car(car(signal~>pins)~>fig)~>bBox
            pin =dbTransformBBox(bBox schInst~>transform)

            wireId = schCreateWire( sch "draw" "full" list(centerBox(pin) rodAddToX(centerBox(pin) 0.05) )  0.0625 0.0625 0.0 )
            schCreateWireLabel( sch car(wireId) rodAddToX(centerBox(pin) 0.125)  "CP<6>" "lowerLeft" "R0" "stick" 0.0625 nil )

            signal = (setof sig schLib~>signals (member "C8" sig~>sigNames))
            bBox = car(car(signal~>pins)~>fig)~>bBox
            pin =dbTransformBBox(bBox schInst~>transform)

            wireId = schCreateWire( sch "draw" "full" list(centerBox(pin) rodAddToX(centerBox(pin) 0.05) )  0.0625 0.0625 0.0 )
            schCreateWireLabel( sch car(wireId) rodAddToX(centerBox(pin) 0.125)  "CP<6>" "lowerLeft" "R0" "stick" 0.0625 nil )

            signal = (setof sig schLib~>signals (member "C16" sig~>sigNames))
            bBox = car(car(signal~>pins)~>fig)~>bBox
            pin =dbTransformBBox(bBox schInst~>transform)

            wireId = schCreateWire( sch "draw" "full" list(centerBox(pin) rodAddToX(centerBox(pin) 0.05) )  0.0625 0.0625 0.0 )
            schCreateWireLabel( sch car(wireId) rodAddToX(centerBox(pin) 0.125)  "CP<7>" "lowerLeft" "R0" "stick" 0.0625 nil )

            signal = (setof sig schLib~>signals (member "CTOP" sig~>sigNames))
            bBox = car(car(signal~>pins)~>fig)~>bBox
            pin =dbTransformBBox(bBox schInst~>transform)

            wireId = schCreateWire( sch "draw" "full" list(centerBox(pin) rodAddToX(centerBox(pin) 0.05) )  0.0625 0.0625 0.0 )
            schCreateWireLabel( sch car(wireId) rodAddToX(centerBox(pin) 0.125)  "CTOP" "lowerLeft" "R0" "stick" 0.0625 nil )

            signal = (setof sig schLib~>signals (member "AVSS" sig~>sigNames))
            bBox = car(car(signal~>pins)~>fig)~>bBox
            pin =dbTransformBBox(bBox schInst~>transform)

            wireId = schCreateWire( sch "draw" "full" list(centerBox(pin) rodAddToX(centerBox(pin) 0.05) )  0.0625 0.0625 0.0 )
            schCreateWireLabel( sch car(wireId) rodAddToX(centerBox(pin) 0.125)  "AVSS" "lowerLeft" "R0" "stick" 0.0625 nil )

    ;;-------------------------------------------------------------------
    ;; Create instance XCS
    ;;-------------------------------------------------------------------
        schLib = dbOpenCellViewByType("SAR9B" "CAP32C_CV" "symbol")
        schInst=dbCreateInst(sch schLib "XCS" xcoord:ycoord "R180")
        xcoord = xcoord  + rightEdge(schLib->bBox) - leftEdge(schLib->bBox) + 1
        if(xcoord > 15 then
                    xcoord = 2
                    ycoord = ycoord +  topEdge(schLib->bBox) - bottomEdge(schLib->bBox) + 1
        )

            signal = (setof sig schLib~>signals (member "C1A" sig~>sigNames))
            bBox = car(car(signal~>pins)~>fig)~>bBox
            pin =dbTransformBBox(bBox schInst~>transform)

            wireId = schCreateWire( sch "draw" "full" list(centerBox(pin) rodAddToX(centerBox(pin) 0.05) )  0.0625 0.0625 0.0 )
            schCreateWireLabel( sch car(wireId) rodAddToX(centerBox(pin) 0.125)  "AVSS" "lowerLeft" "R0" "stick" 0.0625 nil )

            signal = (setof sig schLib~>signals (member "C1B" sig~>sigNames))
            bBox = car(car(signal~>pins)~>fig)~>bBox
            pin =dbTransformBBox(bBox schInst~>transform)

            wireId = schCreateWire( sch "draw" "full" list(centerBox(pin) rodAddToX(centerBox(pin) 0.05) )  0.0625 0.0625 0.0 )
            schCreateWireLabel( sch car(wireId) rodAddToX(centerBox(pin) 0.125)  "CP<0>" "lowerLeft" "R0" "stick" 0.0625 nil )

            signal = (setof sig schLib~>signals (member "C2" sig~>sigNames))
            bBox = car(car(signal~>pins)~>fig)~>bBox
            pin =dbTransformBBox(bBox schInst~>transform)

            wireId = schCreateWire( sch "draw" "full" list(centerBox(pin) rodAddToX(centerBox(pin) 0.05) )  0.0625 0.0625 0.0 )
            schCreateWireLabel( sch car(wireId) rodAddToX(centerBox(pin) 0.125)  "CP<1>" "lowerLeft" "R0" "stick" 0.0625 nil )

            signal = (setof sig schLib~>signals (member "C4" sig~>sigNames))
            bBox = car(car(signal~>pins)~>fig)~>bBox
            pin =dbTransformBBox(bBox schInst~>transform)

            wireId = schCreateWire( sch "draw" "full" list(centerBox(pin) rodAddToX(centerBox(pin) 0.05) )  0.0625 0.0625 0.0 )
            schCreateWireLabel( sch car(wireId) rodAddToX(centerBox(pin) 0.125)  "CP<2>" "lowerLeft" "R0" "stick" 0.0625 nil )

            signal = (setof sig schLib~>signals (member "C8" sig~>sigNames))
            bBox = car(car(signal~>pins)~>fig)~>bBox
            pin =dbTransformBBox(bBox schInst~>transform)

            wireId = schCreateWire( sch "draw" "full" list(centerBox(pin) rodAddToX(centerBox(pin) 0.05) )  0.0625 0.0625 0.0 )
            schCreateWireLabel( sch car(wireId) rodAddToX(centerBox(pin) 0.125)  "CP<3>" "lowerLeft" "R0" "stick" 0.0625 nil )

            signal = (setof sig schLib~>signals (member "C16" sig~>sigNames))
            bBox = car(car(signal~>pins)~>fig)~>bBox
            pin =dbTransformBBox(bBox schInst~>transform)

            wireId = schCreateWire( sch "draw" "full" list(centerBox(pin) rodAddToX(centerBox(pin) 0.05) )  0.0625 0.0625 0.0 )
            schCreateWireLabel( sch car(wireId) rodAddToX(centerBox(pin) 0.125)  "AVSS" "lowerLeft" "R0" "stick" 0.0625 nil )

            signal = (setof sig schLib~>signals (member "CTOP" sig~>sigNames))
            bBox = car(car(signal~>pins)~>fig)~>bBox
            pin =dbTransformBBox(bBox schInst~>transform)

            wireId = schCreateWire( sch "draw" "full" list(centerBox(pin) rodAddToX(centerBox(pin) 0.05) )  0.0625 0.0625 0.0 )
            schCreateWireLabel( sch car(wireId) rodAddToX(centerBox(pin) 0.125)  "CTOP" "lowerLeft" "R0" "stick" 0.0625 nil )

            signal = (setof sig schLib~>signals (member "AVSS" sig~>sigNames))
            bBox = car(car(signal~>pins)~>fig)~>bBox
            pin =dbTransformBBox(bBox schInst~>transform)

            wireId = schCreateWire( sch "draw" "full" list(centerBox(pin) rodAddToX(centerBox(pin) 0.05) )  0.0625 0.0625 0.0 )
            schCreateWireLabel( sch car(wireId) rodAddToX(centerBox(pin) 0.125)  "AVSS" "lowerLeft" "R0" "stick" 0.0625 nil )

    ;;-------------------------------------------------------------------
    ;; Create instance XC128a<1>
    ;;-------------------------------------------------------------------
        schLib = dbOpenCellViewByType("SAR9B" "CAP32C_CV" "symbol")
        schInst=dbCreateInst(sch schLib "XC128a<1>" xcoord:ycoord "R180")
        xcoord = xcoord  + rightEdge(schLib->bBox) - leftEdge(schLib->bBox) + 1
        if(xcoord > 15 then
                    xcoord = 2
                    ycoord = ycoord +  topEdge(schLib->bBox) - bottomEdge(schLib->bBox) + 1
        )

            signal = (setof sig schLib~>signals (member "C1A" sig~>sigNames))
            bBox = car(car(signal~>pins)~>fig)~>bBox
            pin =dbTransformBBox(bBox schInst~>transform)

            wireId = schCreateWire( sch "draw" "full" list(centerBox(pin) rodAddToX(centerBox(pin) 0.05) )  0.0625 0.0625 0.0 )
            schCreateWireLabel( sch car(wireId) rodAddToX(centerBox(pin) 0.125)  "CP<11>" "lowerLeft" "R0" "stick" 0.0625 nil )

            signal = (setof sig schLib~>signals (member "C1B" sig~>sigNames))
            bBox = car(car(signal~>pins)~>fig)~>bBox
            pin =dbTransformBBox(bBox schInst~>transform)

            wireId = schCreateWire( sch "draw" "full" list(centerBox(pin) rodAddToX(centerBox(pin) 0.05) )  0.0625 0.0625 0.0 )
            schCreateWireLabel( sch car(wireId) rodAddToX(centerBox(pin) 0.125)  "CP<11>" "lowerLeft" "R0" "stick" 0.0625 nil )

            signal = (setof sig schLib~>signals (member "C2" sig~>sigNames))
            bBox = car(car(signal~>pins)~>fig)~>bBox
            pin =dbTransformBBox(bBox schInst~>transform)

            wireId = schCreateWire( sch "draw" "full" list(centerBox(pin) rodAddToX(centerBox(pin) 0.05) )  0.0625 0.0625 0.0 )
            schCreateWireLabel( sch car(wireId) rodAddToX(centerBox(pin) 0.125)  "CP<11>" "lowerLeft" "R0" "stick" 0.0625 nil )

            signal = (setof sig schLib~>signals (member "C4" sig~>sigNames))
            bBox = car(car(signal~>pins)~>fig)~>bBox
            pin =dbTransformBBox(bBox schInst~>transform)

            wireId = schCreateWire( sch "draw" "full" list(centerBox(pin) rodAddToX(centerBox(pin) 0.05) )  0.0625 0.0625 0.0 )
            schCreateWireLabel( sch car(wireId) rodAddToX(centerBox(pin) 0.125)  "CP<11>" "lowerLeft" "R0" "stick" 0.0625 nil )

            signal = (setof sig schLib~>signals (member "C8" sig~>sigNames))
            bBox = car(car(signal~>pins)~>fig)~>bBox
            pin =dbTransformBBox(bBox schInst~>transform)

            wireId = schCreateWire( sch "draw" "full" list(centerBox(pin) rodAddToX(centerBox(pin) 0.05) )  0.0625 0.0625 0.0 )
            schCreateWireLabel( sch car(wireId) rodAddToX(centerBox(pin) 0.125)  "CP<11>" "lowerLeft" "R0" "stick" 0.0625 nil )

            signal = (setof sig schLib~>signals (member "C16" sig~>sigNames))
            bBox = car(car(signal~>pins)~>fig)~>bBox
            pin =dbTransformBBox(bBox schInst~>transform)

            wireId = schCreateWire( sch "draw" "full" list(centerBox(pin) rodAddToX(centerBox(pin) 0.05) )  0.0625 0.0625 0.0 )
            schCreateWireLabel( sch car(wireId) rodAddToX(centerBox(pin) 0.125)  "CP<11>" "lowerLeft" "R0" "stick" 0.0625 nil )

            signal = (setof sig schLib~>signals (member "CTOP" sig~>sigNames))
            bBox = car(car(signal~>pins)~>fig)~>bBox
            pin =dbTransformBBox(bBox schInst~>transform)

            wireId = schCreateWire( sch "draw" "full" list(centerBox(pin) rodAddToX(centerBox(pin) 0.05) )  0.0625 0.0625 0.0 )
            schCreateWireLabel( sch car(wireId) rodAddToX(centerBox(pin) 0.125)  "CTOP" "lowerLeft" "R0" "stick" 0.0625 nil )

            signal = (setof sig schLib~>signals (member "AVSS" sig~>sigNames))
            bBox = car(car(signal~>pins)~>fig)~>bBox
            pin =dbTransformBBox(bBox schInst~>transform)

            wireId = schCreateWire( sch "draw" "full" list(centerBox(pin) rodAddToX(centerBox(pin) 0.05) )  0.0625 0.0625 0.0 )
            schCreateWireLabel( sch car(wireId) rodAddToX(centerBox(pin) 0.125)  "AVSS" "lowerLeft" "R0" "stick" 0.0625 nil )

    ;;-------------------------------------------------------------------
    ;; Create instance XC256b<5>
    ;;-------------------------------------------------------------------
        schLib = dbOpenCellViewByType("SAR9B" "CAP32C_CV" "symbol")
        schInst=dbCreateInst(sch schLib "XC256b<5>" xcoord:ycoord "R180")
        xcoord = xcoord  + rightEdge(schLib->bBox) - leftEdge(schLib->bBox) + 1
        if(xcoord > 15 then
                    xcoord = 2
                    ycoord = ycoord +  topEdge(schLib->bBox) - bottomEdge(schLib->bBox) + 1
        )

            signal = (setof sig schLib~>signals (member "C1A" sig~>sigNames))
            bBox = car(car(signal~>pins)~>fig)~>bBox
            pin =dbTransformBBox(bBox schInst~>transform)

            wireId = schCreateWire( sch "draw" "full" list(centerBox(pin) rodAddToX(centerBox(pin) 0.05) )  0.0625 0.0625 0.0 )
            schCreateWireLabel( sch car(wireId) rodAddToX(centerBox(pin) 0.125)  "CP<12>" "lowerLeft" "R0" "stick" 0.0625 nil )

            signal = (setof sig schLib~>signals (member "C1B" sig~>sigNames))
            bBox = car(car(signal~>pins)~>fig)~>bBox
            pin =dbTransformBBox(bBox schInst~>transform)

            wireId = schCreateWire( sch "draw" "full" list(centerBox(pin) rodAddToX(centerBox(pin) 0.05) )  0.0625 0.0625 0.0 )
            schCreateWireLabel( sch car(wireId) rodAddToX(centerBox(pin) 0.125)  "CP<12>" "lowerLeft" "R0" "stick" 0.0625 nil )

            signal = (setof sig schLib~>signals (member "C2" sig~>sigNames))
            bBox = car(car(signal~>pins)~>fig)~>bBox
            pin =dbTransformBBox(bBox schInst~>transform)

            wireId = schCreateWire( sch "draw" "full" list(centerBox(pin) rodAddToX(centerBox(pin) 0.05) )  0.0625 0.0625 0.0 )
            schCreateWireLabel( sch car(wireId) rodAddToX(centerBox(pin) 0.125)  "CP<12>" "lowerLeft" "R0" "stick" 0.0625 nil )

            signal = (setof sig schLib~>signals (member "C4" sig~>sigNames))
            bBox = car(car(signal~>pins)~>fig)~>bBox
            pin =dbTransformBBox(bBox schInst~>transform)

            wireId = schCreateWire( sch "draw" "full" list(centerBox(pin) rodAddToX(centerBox(pin) 0.05) )  0.0625 0.0625 0.0 )
            schCreateWireLabel( sch car(wireId) rodAddToX(centerBox(pin) 0.125)  "CP<12>" "lowerLeft" "R0" "stick" 0.0625 nil )

            signal = (setof sig schLib~>signals (member "C8" sig~>sigNames))
            bBox = car(car(signal~>pins)~>fig)~>bBox
            pin =dbTransformBBox(bBox schInst~>transform)

            wireId = schCreateWire( sch "draw" "full" list(centerBox(pin) rodAddToX(centerBox(pin) 0.05) )  0.0625 0.0625 0.0 )
            schCreateWireLabel( sch car(wireId) rodAddToX(centerBox(pin) 0.125)  "CP<12>" "lowerLeft" "R0" "stick" 0.0625 nil )

            signal = (setof sig schLib~>signals (member "C16" sig~>sigNames))
            bBox = car(car(signal~>pins)~>fig)~>bBox
            pin =dbTransformBBox(bBox schInst~>transform)

            wireId = schCreateWire( sch "draw" "full" list(centerBox(pin) rodAddToX(centerBox(pin) 0.05) )  0.0625 0.0625 0.0 )
            schCreateWireLabel( sch car(wireId) rodAddToX(centerBox(pin) 0.125)  "CP<12>" "lowerLeft" "R0" "stick" 0.0625 nil )

            signal = (setof sig schLib~>signals (member "CTOP" sig~>sigNames))
            bBox = car(car(signal~>pins)~>fig)~>bBox
            pin =dbTransformBBox(bBox schInst~>transform)

            wireId = schCreateWire( sch "draw" "full" list(centerBox(pin) rodAddToX(centerBox(pin) 0.05) )  0.0625 0.0625 0.0 )
            schCreateWireLabel( sch car(wireId) rodAddToX(centerBox(pin) 0.125)  "CTOP" "lowerLeft" "R0" "stick" 0.0625 nil )

            signal = (setof sig schLib~>signals (member "AVSS" sig~>sigNames))
            bBox = car(car(signal~>pins)~>fig)~>bBox
            pin =dbTransformBBox(bBox schInst~>transform)

            wireId = schCreateWire( sch "draw" "full" list(centerBox(pin) rodAddToX(centerBox(pin) 0.05) )  0.0625 0.0625 0.0 )
            schCreateWireLabel( sch car(wireId) rodAddToX(centerBox(pin) 0.125)  "AVSS" "lowerLeft" "R0" "stick" 0.0625 nil )

    ;;-------------------------------------------------------------------
    ;; Create instance XC256a<5>
    ;;-------------------------------------------------------------------
        schLib = dbOpenCellViewByType("SAR9B" "CAP32C_CV" "symbol")
        schInst=dbCreateInst(sch schLib "XC256a<5>" xcoord:ycoord "R180")
        xcoord = xcoord  + rightEdge(schLib->bBox) - leftEdge(schLib->bBox) + 1
        if(xcoord > 15 then
                    xcoord = 2
                    ycoord = ycoord +  topEdge(schLib->bBox) - bottomEdge(schLib->bBox) + 1
        )

            signal = (setof sig schLib~>signals (member "C1A" sig~>sigNames))
            bBox = car(car(signal~>pins)~>fig)~>bBox
            pin =dbTransformBBox(bBox schInst~>transform)

            wireId = schCreateWire( sch "draw" "full" list(centerBox(pin) rodAddToX(centerBox(pin) 0.05) )  0.0625 0.0625 0.0 )
            schCreateWireLabel( sch car(wireId) rodAddToX(centerBox(pin) 0.125)  "CP<13>" "lowerLeft" "R0" "stick" 0.0625 nil )

            signal = (setof sig schLib~>signals (member "C1B" sig~>sigNames))
            bBox = car(car(signal~>pins)~>fig)~>bBox
            pin =dbTransformBBox(bBox schInst~>transform)

            wireId = schCreateWire( sch "draw" "full" list(centerBox(pin) rodAddToX(centerBox(pin) 0.05) )  0.0625 0.0625 0.0 )
            schCreateWireLabel( sch car(wireId) rodAddToX(centerBox(pin) 0.125)  "CP<13>" "lowerLeft" "R0" "stick" 0.0625 nil )

            signal = (setof sig schLib~>signals (member "C2" sig~>sigNames))
            bBox = car(car(signal~>pins)~>fig)~>bBox
            pin =dbTransformBBox(bBox schInst~>transform)

            wireId = schCreateWire( sch "draw" "full" list(centerBox(pin) rodAddToX(centerBox(pin) 0.05) )  0.0625 0.0625 0.0 )
            schCreateWireLabel( sch car(wireId) rodAddToX(centerBox(pin) 0.125)  "CP<13>" "lowerLeft" "R0" "stick" 0.0625 nil )

            signal = (setof sig schLib~>signals (member "C4" sig~>sigNames))
            bBox = car(car(signal~>pins)~>fig)~>bBox
            pin =dbTransformBBox(bBox schInst~>transform)

            wireId = schCreateWire( sch "draw" "full" list(centerBox(pin) rodAddToX(centerBox(pin) 0.05) )  0.0625 0.0625 0.0 )
            schCreateWireLabel( sch car(wireId) rodAddToX(centerBox(pin) 0.125)  "CP<13>" "lowerLeft" "R0" "stick" 0.0625 nil )

            signal = (setof sig schLib~>signals (member "C8" sig~>sigNames))
            bBox = car(car(signal~>pins)~>fig)~>bBox
            pin =dbTransformBBox(bBox schInst~>transform)

            wireId = schCreateWire( sch "draw" "full" list(centerBox(pin) rodAddToX(centerBox(pin) 0.05) )  0.0625 0.0625 0.0 )
            schCreateWireLabel( sch car(wireId) rodAddToX(centerBox(pin) 0.125)  "CP<13>" "lowerLeft" "R0" "stick" 0.0625 nil )

            signal = (setof sig schLib~>signals (member "C16" sig~>sigNames))
            bBox = car(car(signal~>pins)~>fig)~>bBox
            pin =dbTransformBBox(bBox schInst~>transform)

            wireId = schCreateWire( sch "draw" "full" list(centerBox(pin) rodAddToX(centerBox(pin) 0.05) )  0.0625 0.0625 0.0 )
            schCreateWireLabel( sch car(wireId) rodAddToX(centerBox(pin) 0.125)  "CP<13>" "lowerLeft" "R0" "stick" 0.0625 nil )

            signal = (setof sig schLib~>signals (member "CTOP" sig~>sigNames))
            bBox = car(car(signal~>pins)~>fig)~>bBox
            pin =dbTransformBBox(bBox schInst~>transform)

            wireId = schCreateWire( sch "draw" "full" list(centerBox(pin) rodAddToX(centerBox(pin) 0.05) )  0.0625 0.0625 0.0 )
            schCreateWireLabel( sch car(wireId) rodAddToX(centerBox(pin) 0.125)  "CTOP" "lowerLeft" "R0" "stick" 0.0625 nil )

            signal = (setof sig schLib~>signals (member "AVSS" sig~>sigNames))
            bBox = car(car(signal~>pins)~>fig)~>bBox
            pin =dbTransformBBox(bBox schInst~>transform)

            wireId = schCreateWire( sch "draw" "full" list(centerBox(pin) rodAddToX(centerBox(pin) 0.05) )  0.0625 0.0625 0.0 )
            schCreateWireLabel( sch car(wireId) rodAddToX(centerBox(pin) 0.125)  "AVSS" "lowerLeft" "R0" "stick" 0.0625 nil )

    ;;-------------------------------------------------------------------
    ;; Create instance XC256b<2>
    ;;-------------------------------------------------------------------
        schLib = dbOpenCellViewByType("SAR9B" "CAP32C_CV" "symbol")
        schInst=dbCreateInst(sch schLib "XC256b<2>" xcoord:ycoord "R180")
        xcoord = xcoord  + rightEdge(schLib->bBox) - leftEdge(schLib->bBox) + 1
        if(xcoord > 15 then
                    xcoord = 2
                    ycoord = ycoord +  topEdge(schLib->bBox) - bottomEdge(schLib->bBox) + 1
        )

            signal = (setof sig schLib~>signals (member "C1A" sig~>sigNames))
            bBox = car(car(signal~>pins)~>fig)~>bBox
            pin =dbTransformBBox(bBox schInst~>transform)

            wireId = schCreateWire( sch "draw" "full" list(centerBox(pin) rodAddToX(centerBox(pin) 0.05) )  0.0625 0.0625 0.0 )
            schCreateWireLabel( sch car(wireId) rodAddToX(centerBox(pin) 0.125)  "CP<12>" "lowerLeft" "R0" "stick" 0.0625 nil )

            signal = (setof sig schLib~>signals (member "C1B" sig~>sigNames))
            bBox = car(car(signal~>pins)~>fig)~>bBox
            pin =dbTransformBBox(bBox schInst~>transform)

            wireId = schCreateWire( sch "draw" "full" list(centerBox(pin) rodAddToX(centerBox(pin) 0.05) )  0.0625 0.0625 0.0 )
            schCreateWireLabel( sch car(wireId) rodAddToX(centerBox(pin) 0.125)  "CP<12>" "lowerLeft" "R0" "stick" 0.0625 nil )

            signal = (setof sig schLib~>signals (member "C2" sig~>sigNames))
            bBox = car(car(signal~>pins)~>fig)~>bBox
            pin =dbTransformBBox(bBox schInst~>transform)

            wireId = schCreateWire( sch "draw" "full" list(centerBox(pin) rodAddToX(centerBox(pin) 0.05) )  0.0625 0.0625 0.0 )
            schCreateWireLabel( sch car(wireId) rodAddToX(centerBox(pin) 0.125)  "CP<12>" "lowerLeft" "R0" "stick" 0.0625 nil )

            signal = (setof sig schLib~>signals (member "C4" sig~>sigNames))
            bBox = car(car(signal~>pins)~>fig)~>bBox
            pin =dbTransformBBox(bBox schInst~>transform)

            wireId = schCreateWire( sch "draw" "full" list(centerBox(pin) rodAddToX(centerBox(pin) 0.05) )  0.0625 0.0625 0.0 )
            schCreateWireLabel( sch car(wireId) rodAddToX(centerBox(pin) 0.125)  "CP<12>" "lowerLeft" "R0" "stick" 0.0625 nil )

            signal = (setof sig schLib~>signals (member "C8" sig~>sigNames))
            bBox = car(car(signal~>pins)~>fig)~>bBox
            pin =dbTransformBBox(bBox schInst~>transform)

            wireId = schCreateWire( sch "draw" "full" list(centerBox(pin) rodAddToX(centerBox(pin) 0.05) )  0.0625 0.0625 0.0 )
            schCreateWireLabel( sch car(wireId) rodAddToX(centerBox(pin) 0.125)  "CP<12>" "lowerLeft" "R0" "stick" 0.0625 nil )

            signal = (setof sig schLib~>signals (member "C16" sig~>sigNames))
            bBox = car(car(signal~>pins)~>fig)~>bBox
            pin =dbTransformBBox(bBox schInst~>transform)

            wireId = schCreateWire( sch "draw" "full" list(centerBox(pin) rodAddToX(centerBox(pin) 0.05) )  0.0625 0.0625 0.0 )
            schCreateWireLabel( sch car(wireId) rodAddToX(centerBox(pin) 0.125)  "CP<12>" "lowerLeft" "R0" "stick" 0.0625 nil )

            signal = (setof sig schLib~>signals (member "CTOP" sig~>sigNames))
            bBox = car(car(signal~>pins)~>fig)~>bBox
            pin =dbTransformBBox(bBox schInst~>transform)

            wireId = schCreateWire( sch "draw" "full" list(centerBox(pin) rodAddToX(centerBox(pin) 0.05) )  0.0625 0.0625 0.0 )
            schCreateWireLabel( sch car(wireId) rodAddToX(centerBox(pin) 0.125)  "CTOP" "lowerLeft" "R0" "stick" 0.0625 nil )

            signal = (setof sig schLib~>signals (member "AVSS" sig~>sigNames))
            bBox = car(car(signal~>pins)~>fig)~>bBox
            pin =dbTransformBBox(bBox schInst~>transform)

            wireId = schCreateWire( sch "draw" "full" list(centerBox(pin) rodAddToX(centerBox(pin) 0.05) )  0.0625 0.0625 0.0 )
            schCreateWireLabel( sch car(wireId) rodAddToX(centerBox(pin) 0.125)  "AVSS" "lowerLeft" "R0" "stick" 0.0625 nil )

    ;;-------------------------------------------------------------------
    ;; Create instance XC256a<2>
    ;;-------------------------------------------------------------------
        schLib = dbOpenCellViewByType("SAR9B" "CAP32C_CV" "symbol")
        schInst=dbCreateInst(sch schLib "XC256a<2>" xcoord:ycoord "R180")
        xcoord = xcoord  + rightEdge(schLib->bBox) - leftEdge(schLib->bBox) + 1
        if(xcoord > 15 then
                    xcoord = 2
                    ycoord = ycoord +  topEdge(schLib->bBox) - bottomEdge(schLib->bBox) + 1
        )

            signal = (setof sig schLib~>signals (member "C1A" sig~>sigNames))
            bBox = car(car(signal~>pins)~>fig)~>bBox
            pin =dbTransformBBox(bBox schInst~>transform)

            wireId = schCreateWire( sch "draw" "full" list(centerBox(pin) rodAddToX(centerBox(pin) 0.05) )  0.0625 0.0625 0.0 )
            schCreateWireLabel( sch car(wireId) rodAddToX(centerBox(pin) 0.125)  "CP<13>" "lowerLeft" "R0" "stick" 0.0625 nil )

            signal = (setof sig schLib~>signals (member "C1B" sig~>sigNames))
            bBox = car(car(signal~>pins)~>fig)~>bBox
            pin =dbTransformBBox(bBox schInst~>transform)

            wireId = schCreateWire( sch "draw" "full" list(centerBox(pin) rodAddToX(centerBox(pin) 0.05) )  0.0625 0.0625 0.0 )
            schCreateWireLabel( sch car(wireId) rodAddToX(centerBox(pin) 0.125)  "CP<13>" "lowerLeft" "R0" "stick" 0.0625 nil )

            signal = (setof sig schLib~>signals (member "C2" sig~>sigNames))
            bBox = car(car(signal~>pins)~>fig)~>bBox
            pin =dbTransformBBox(bBox schInst~>transform)

            wireId = schCreateWire( sch "draw" "full" list(centerBox(pin) rodAddToX(centerBox(pin) 0.05) )  0.0625 0.0625 0.0 )
            schCreateWireLabel( sch car(wireId) rodAddToX(centerBox(pin) 0.125)  "CP<13>" "lowerLeft" "R0" "stick" 0.0625 nil )

            signal = (setof sig schLib~>signals (member "C4" sig~>sigNames))
            bBox = car(car(signal~>pins)~>fig)~>bBox
            pin =dbTransformBBox(bBox schInst~>transform)

            wireId = schCreateWire( sch "draw" "full" list(centerBox(pin) rodAddToX(centerBox(pin) 0.05) )  0.0625 0.0625 0.0 )
            schCreateWireLabel( sch car(wireId) rodAddToX(centerBox(pin) 0.125)  "CP<13>" "lowerLeft" "R0" "stick" 0.0625 nil )

            signal = (setof sig schLib~>signals (member "C8" sig~>sigNames))
            bBox = car(car(signal~>pins)~>fig)~>bBox
            pin =dbTransformBBox(bBox schInst~>transform)

            wireId = schCreateWire( sch "draw" "full" list(centerBox(pin) rodAddToX(centerBox(pin) 0.05) )  0.0625 0.0625 0.0 )
            schCreateWireLabel( sch car(wireId) rodAddToX(centerBox(pin) 0.125)  "CP<13>" "lowerLeft" "R0" "stick" 0.0625 nil )

            signal = (setof sig schLib~>signals (member "C16" sig~>sigNames))
            bBox = car(car(signal~>pins)~>fig)~>bBox
            pin =dbTransformBBox(bBox schInst~>transform)

            wireId = schCreateWire( sch "draw" "full" list(centerBox(pin) rodAddToX(centerBox(pin) 0.05) )  0.0625 0.0625 0.0 )
            schCreateWireLabel( sch car(wireId) rodAddToX(centerBox(pin) 0.125)  "CP<13>" "lowerLeft" "R0" "stick" 0.0625 nil )

            signal = (setof sig schLib~>signals (member "CTOP" sig~>sigNames))
            bBox = car(car(signal~>pins)~>fig)~>bBox
            pin =dbTransformBBox(bBox schInst~>transform)

            wireId = schCreateWire( sch "draw" "full" list(centerBox(pin) rodAddToX(centerBox(pin) 0.05) )  0.0625 0.0625 0.0 )
            schCreateWireLabel( sch car(wireId) rodAddToX(centerBox(pin) 0.125)  "CTOP" "lowerLeft" "R0" "stick" 0.0625 nil )

            signal = (setof sig schLib~>signals (member "AVSS" sig~>sigNames))
            bBox = car(car(signal~>pins)~>fig)~>bBox
            pin =dbTransformBBox(bBox schInst~>transform)

            wireId = schCreateWire( sch "draw" "full" list(centerBox(pin) rodAddToX(centerBox(pin) 0.05) )  0.0625 0.0625 0.0 )
            schCreateWireLabel( sch car(wireId) rodAddToX(centerBox(pin) 0.125)  "AVSS" "lowerLeft" "R0" "stick" 0.0625 nil )

    ;;-------------------------------------------------------------------
    ;; Create instance XC128b<2>
    ;;-------------------------------------------------------------------
        schLib = dbOpenCellViewByType("SAR9B" "CAP32C_CV" "symbol")
        schInst=dbCreateInst(sch schLib "XC128b<2>" xcoord:ycoord "R180")
        xcoord = xcoord  + rightEdge(schLib->bBox) - leftEdge(schLib->bBox) + 1
        if(xcoord > 15 then
                    xcoord = 2
                    ycoord = ycoord +  topEdge(schLib->bBox) - bottomEdge(schLib->bBox) + 1
        )

            signal = (setof sig schLib~>signals (member "C1A" sig~>sigNames))
            bBox = car(car(signal~>pins)~>fig)~>bBox
            pin =dbTransformBBox(bBox schInst~>transform)

            wireId = schCreateWire( sch "draw" "full" list(centerBox(pin) rodAddToX(centerBox(pin) 0.05) )  0.0625 0.0625 0.0 )
            schCreateWireLabel( sch car(wireId) rodAddToX(centerBox(pin) 0.125)  "CP<10>" "lowerLeft" "R0" "stick" 0.0625 nil )

            signal = (setof sig schLib~>signals (member "C1B" sig~>sigNames))
            bBox = car(car(signal~>pins)~>fig)~>bBox
            pin =dbTransformBBox(bBox schInst~>transform)

            wireId = schCreateWire( sch "draw" "full" list(centerBox(pin) rodAddToX(centerBox(pin) 0.05) )  0.0625 0.0625 0.0 )
            schCreateWireLabel( sch car(wireId) rodAddToX(centerBox(pin) 0.125)  "CP<10>" "lowerLeft" "R0" "stick" 0.0625 nil )

            signal = (setof sig schLib~>signals (member "C2" sig~>sigNames))
            bBox = car(car(signal~>pins)~>fig)~>bBox
            pin =dbTransformBBox(bBox schInst~>transform)

            wireId = schCreateWire( sch "draw" "full" list(centerBox(pin) rodAddToX(centerBox(pin) 0.05) )  0.0625 0.0625 0.0 )
            schCreateWireLabel( sch car(wireId) rodAddToX(centerBox(pin) 0.125)  "CP<10>" "lowerLeft" "R0" "stick" 0.0625 nil )

            signal = (setof sig schLib~>signals (member "C4" sig~>sigNames))
            bBox = car(car(signal~>pins)~>fig)~>bBox
            pin =dbTransformBBox(bBox schInst~>transform)

            wireId = schCreateWire( sch "draw" "full" list(centerBox(pin) rodAddToX(centerBox(pin) 0.05) )  0.0625 0.0625 0.0 )
            schCreateWireLabel( sch car(wireId) rodAddToX(centerBox(pin) 0.125)  "CP<10>" "lowerLeft" "R0" "stick" 0.0625 nil )

            signal = (setof sig schLib~>signals (member "C8" sig~>sigNames))
            bBox = car(car(signal~>pins)~>fig)~>bBox
            pin =dbTransformBBox(bBox schInst~>transform)

            wireId = schCreateWire( sch "draw" "full" list(centerBox(pin) rodAddToX(centerBox(pin) 0.05) )  0.0625 0.0625 0.0 )
            schCreateWireLabel( sch car(wireId) rodAddToX(centerBox(pin) 0.125)  "CP<10>" "lowerLeft" "R0" "stick" 0.0625 nil )

            signal = (setof sig schLib~>signals (member "C16" sig~>sigNames))
            bBox = car(car(signal~>pins)~>fig)~>bBox
            pin =dbTransformBBox(bBox schInst~>transform)

            wireId = schCreateWire( sch "draw" "full" list(centerBox(pin) rodAddToX(centerBox(pin) 0.05) )  0.0625 0.0625 0.0 )
            schCreateWireLabel( sch car(wireId) rodAddToX(centerBox(pin) 0.125)  "CP<10>" "lowerLeft" "R0" "stick" 0.0625 nil )

            signal = (setof sig schLib~>signals (member "CTOP" sig~>sigNames))
            bBox = car(car(signal~>pins)~>fig)~>bBox
            pin =dbTransformBBox(bBox schInst~>transform)

            wireId = schCreateWire( sch "draw" "full" list(centerBox(pin) rodAddToX(centerBox(pin) 0.05) )  0.0625 0.0625 0.0 )
            schCreateWireLabel( sch car(wireId) rodAddToX(centerBox(pin) 0.125)  "CTOP" "lowerLeft" "R0" "stick" 0.0625 nil )

            signal = (setof sig schLib~>signals (member "AVSS" sig~>sigNames))
            bBox = car(car(signal~>pins)~>fig)~>bBox
            pin =dbTransformBBox(bBox schInst~>transform)

            wireId = schCreateWire( sch "draw" "full" list(centerBox(pin) rodAddToX(centerBox(pin) 0.05) )  0.0625 0.0625 0.0 )
            schCreateWireLabel( sch car(wireId) rodAddToX(centerBox(pin) 0.125)  "AVSS" "lowerLeft" "R0" "stick" 0.0625 nil )

    ;;-------------------------------------------------------------------
    ;; Create instance X16ab
    ;;-------------------------------------------------------------------
        schLib = dbOpenCellViewByType("SAR9B" "CAP32C_CV" "symbol")
        schInst=dbCreateInst(sch schLib "X16ab" xcoord:ycoord "R180")
        xcoord = xcoord  + rightEdge(schLib->bBox) - leftEdge(schLib->bBox) + 1
        if(xcoord > 15 then
                    xcoord = 2
                    ycoord = ycoord +  topEdge(schLib->bBox) - bottomEdge(schLib->bBox) + 1
        )

            signal = (setof sig schLib~>signals (member "C1A" sig~>sigNames))
            bBox = car(car(signal~>pins)~>fig)~>bBox
            pin =dbTransformBBox(bBox schInst~>transform)

            wireId = schCreateWire( sch "draw" "full" list(centerBox(pin) rodAddToX(centerBox(pin) 0.05) )  0.0625 0.0625 0.0 )
            schCreateWireLabel( sch car(wireId) rodAddToX(centerBox(pin) 0.125)  "CP<5>" "lowerLeft" "R0" "stick" 0.0625 nil )

            signal = (setof sig schLib~>signals (member "C1B" sig~>sigNames))
            bBox = car(car(signal~>pins)~>fig)~>bBox
            pin =dbTransformBBox(bBox schInst~>transform)

            wireId = schCreateWire( sch "draw" "full" list(centerBox(pin) rodAddToX(centerBox(pin) 0.05) )  0.0625 0.0625 0.0 )
            schCreateWireLabel( sch car(wireId) rodAddToX(centerBox(pin) 0.125)  "CP<5>" "lowerLeft" "R0" "stick" 0.0625 nil )

            signal = (setof sig schLib~>signals (member "C2" sig~>sigNames))
            bBox = car(car(signal~>pins)~>fig)~>bBox
            pin =dbTransformBBox(bBox schInst~>transform)

            wireId = schCreateWire( sch "draw" "full" list(centerBox(pin) rodAddToX(centerBox(pin) 0.05) )  0.0625 0.0625 0.0 )
            schCreateWireLabel( sch car(wireId) rodAddToX(centerBox(pin) 0.125)  "CP<5>" "lowerLeft" "R0" "stick" 0.0625 nil )

            signal = (setof sig schLib~>signals (member "C4" sig~>sigNames))
            bBox = car(car(signal~>pins)~>fig)~>bBox
            pin =dbTransformBBox(bBox schInst~>transform)

            wireId = schCreateWire( sch "draw" "full" list(centerBox(pin) rodAddToX(centerBox(pin) 0.05) )  0.0625 0.0625 0.0 )
            schCreateWireLabel( sch car(wireId) rodAddToX(centerBox(pin) 0.125)  "CP<5>" "lowerLeft" "R0" "stick" 0.0625 nil )

            signal = (setof sig schLib~>signals (member "C8" sig~>sigNames))
            bBox = car(car(signal~>pins)~>fig)~>bBox
            pin =dbTransformBBox(bBox schInst~>transform)

            wireId = schCreateWire( sch "draw" "full" list(centerBox(pin) rodAddToX(centerBox(pin) 0.05) )  0.0625 0.0625 0.0 )
            schCreateWireLabel( sch car(wireId) rodAddToX(centerBox(pin) 0.125)  "CP<4>" "lowerLeft" "R0" "stick" 0.0625 nil )

            signal = (setof sig schLib~>signals (member "C16" sig~>sigNames))
            bBox = car(car(signal~>pins)~>fig)~>bBox
            pin =dbTransformBBox(bBox schInst~>transform)

            wireId = schCreateWire( sch "draw" "full" list(centerBox(pin) rodAddToX(centerBox(pin) 0.05) )  0.0625 0.0625 0.0 )
            schCreateWireLabel( sch car(wireId) rodAddToX(centerBox(pin) 0.125)  "AVSS" "lowerLeft" "R0" "stick" 0.0625 nil )

            signal = (setof sig schLib~>signals (member "CTOP" sig~>sigNames))
            bBox = car(car(signal~>pins)~>fig)~>bBox
            pin =dbTransformBBox(bBox schInst~>transform)

            wireId = schCreateWire( sch "draw" "full" list(centerBox(pin) rodAddToX(centerBox(pin) 0.05) )  0.0625 0.0625 0.0 )
            schCreateWireLabel( sch car(wireId) rodAddToX(centerBox(pin) 0.125)  "CTOP" "lowerLeft" "R0" "stick" 0.0625 nil )

            signal = (setof sig schLib~>signals (member "AVSS" sig~>sigNames))
            bBox = car(car(signal~>pins)~>fig)~>bBox
            pin =dbTransformBBox(bBox schInst~>transform)

            wireId = schCreateWire( sch "draw" "full" list(centerBox(pin) rodAddToX(centerBox(pin) 0.05) )  0.0625 0.0625 0.0 )
            schCreateWireLabel( sch car(wireId) rodAddToX(centerBox(pin) 0.125)  "AVSS" "lowerLeft" "R0" "stick" 0.0625 nil )

    ;;-------------------------------------------------------------------
    ;; Create instance XC64b<1>
    ;;-------------------------------------------------------------------
        schLib = dbOpenCellViewByType("SAR9B" "CAP32C_CV" "symbol")
        schInst=dbCreateInst(sch schLib "XC64b<1>" xcoord:ycoord "R180")
        xcoord = xcoord  + rightEdge(schLib->bBox) - leftEdge(schLib->bBox) + 1
        if(xcoord > 15 then
                    xcoord = 2
                    ycoord = ycoord +  topEdge(schLib->bBox) - bottomEdge(schLib->bBox) + 1
        )

            signal = (setof sig schLib~>signals (member "C1A" sig~>sigNames))
            bBox = car(car(signal~>pins)~>fig)~>bBox
            pin =dbTransformBBox(bBox schInst~>transform)

            wireId = schCreateWire( sch "draw" "full" list(centerBox(pin) rodAddToX(centerBox(pin) 0.05) )  0.0625 0.0625 0.0 )
            schCreateWireLabel( sch car(wireId) rodAddToX(centerBox(pin) 0.125)  "CP<9>" "lowerLeft" "R0" "stick" 0.0625 nil )

            signal = (setof sig schLib~>signals (member "C1B" sig~>sigNames))
            bBox = car(car(signal~>pins)~>fig)~>bBox
            pin =dbTransformBBox(bBox schInst~>transform)

            wireId = schCreateWire( sch "draw" "full" list(centerBox(pin) rodAddToX(centerBox(pin) 0.05) )  0.0625 0.0625 0.0 )
            schCreateWireLabel( sch car(wireId) rodAddToX(centerBox(pin) 0.125)  "CP<9>" "lowerLeft" "R0" "stick" 0.0625 nil )

            signal = (setof sig schLib~>signals (member "C2" sig~>sigNames))
            bBox = car(car(signal~>pins)~>fig)~>bBox
            pin =dbTransformBBox(bBox schInst~>transform)

            wireId = schCreateWire( sch "draw" "full" list(centerBox(pin) rodAddToX(centerBox(pin) 0.05) )  0.0625 0.0625 0.0 )
            schCreateWireLabel( sch car(wireId) rodAddToX(centerBox(pin) 0.125)  "CP<9>" "lowerLeft" "R0" "stick" 0.0625 nil )

            signal = (setof sig schLib~>signals (member "C4" sig~>sigNames))
            bBox = car(car(signal~>pins)~>fig)~>bBox
            pin =dbTransformBBox(bBox schInst~>transform)

            wireId = schCreateWire( sch "draw" "full" list(centerBox(pin) rodAddToX(centerBox(pin) 0.05) )  0.0625 0.0625 0.0 )
            schCreateWireLabel( sch car(wireId) rodAddToX(centerBox(pin) 0.125)  "CP<9>" "lowerLeft" "R0" "stick" 0.0625 nil )

            signal = (setof sig schLib~>signals (member "C8" sig~>sigNames))
            bBox = car(car(signal~>pins)~>fig)~>bBox
            pin =dbTransformBBox(bBox schInst~>transform)

            wireId = schCreateWire( sch "draw" "full" list(centerBox(pin) rodAddToX(centerBox(pin) 0.05) )  0.0625 0.0625 0.0 )
            schCreateWireLabel( sch car(wireId) rodAddToX(centerBox(pin) 0.125)  "CP<9>" "lowerLeft" "R0" "stick" 0.0625 nil )

            signal = (setof sig schLib~>signals (member "C16" sig~>sigNames))
            bBox = car(car(signal~>pins)~>fig)~>bBox
            pin =dbTransformBBox(bBox schInst~>transform)

            wireId = schCreateWire( sch "draw" "full" list(centerBox(pin) rodAddToX(centerBox(pin) 0.05) )  0.0625 0.0625 0.0 )
            schCreateWireLabel( sch car(wireId) rodAddToX(centerBox(pin) 0.125)  "CP<9>" "lowerLeft" "R0" "stick" 0.0625 nil )

            signal = (setof sig schLib~>signals (member "CTOP" sig~>sigNames))
            bBox = car(car(signal~>pins)~>fig)~>bBox
            pin =dbTransformBBox(bBox schInst~>transform)

            wireId = schCreateWire( sch "draw" "full" list(centerBox(pin) rodAddToX(centerBox(pin) 0.05) )  0.0625 0.0625 0.0 )
            schCreateWireLabel( sch car(wireId) rodAddToX(centerBox(pin) 0.125)  "CTOP" "lowerLeft" "R0" "stick" 0.0625 nil )

            signal = (setof sig schLib~>signals (member "AVSS" sig~>sigNames))
            bBox = car(car(signal~>pins)~>fig)~>bBox
            pin =dbTransformBBox(bBox schInst~>transform)

            wireId = schCreateWire( sch "draw" "full" list(centerBox(pin) rodAddToX(centerBox(pin) 0.05) )  0.0625 0.0625 0.0 )
            schCreateWireLabel( sch car(wireId) rodAddToX(centerBox(pin) 0.125)  "AVSS" "lowerLeft" "R0" "stick" 0.0625 nil )

    ;;-------------------------------------------------------------------
    ;; Create instance XC128a<0>
    ;;-------------------------------------------------------------------
        schLib = dbOpenCellViewByType("SAR9B" "CAP32C_CV" "symbol")
        schInst=dbCreateInst(sch schLib "XC128a<0>" xcoord:ycoord "R180")
        xcoord = xcoord  + rightEdge(schLib->bBox) - leftEdge(schLib->bBox) + 1
        if(xcoord > 15 then
                    xcoord = 2
                    ycoord = ycoord +  topEdge(schLib->bBox) - bottomEdge(schLib->bBox) + 1
        )

            signal = (setof sig schLib~>signals (member "C1A" sig~>sigNames))
            bBox = car(car(signal~>pins)~>fig)~>bBox
            pin =dbTransformBBox(bBox schInst~>transform)

            wireId = schCreateWire( sch "draw" "full" list(centerBox(pin) rodAddToX(centerBox(pin) 0.05) )  0.0625 0.0625 0.0 )
            schCreateWireLabel( sch car(wireId) rodAddToX(centerBox(pin) 0.125)  "CP<11>" "lowerLeft" "R0" "stick" 0.0625 nil )

            signal = (setof sig schLib~>signals (member "C1B" sig~>sigNames))
            bBox = car(car(signal~>pins)~>fig)~>bBox
            pin =dbTransformBBox(bBox schInst~>transform)

            wireId = schCreateWire( sch "draw" "full" list(centerBox(pin) rodAddToX(centerBox(pin) 0.05) )  0.0625 0.0625 0.0 )
            schCreateWireLabel( sch car(wireId) rodAddToX(centerBox(pin) 0.125)  "CP<11>" "lowerLeft" "R0" "stick" 0.0625 nil )

            signal = (setof sig schLib~>signals (member "C2" sig~>sigNames))
            bBox = car(car(signal~>pins)~>fig)~>bBox
            pin =dbTransformBBox(bBox schInst~>transform)

            wireId = schCreateWire( sch "draw" "full" list(centerBox(pin) rodAddToX(centerBox(pin) 0.05) )  0.0625 0.0625 0.0 )
            schCreateWireLabel( sch car(wireId) rodAddToX(centerBox(pin) 0.125)  "CP<11>" "lowerLeft" "R0" "stick" 0.0625 nil )

            signal = (setof sig schLib~>signals (member "C4" sig~>sigNames))
            bBox = car(car(signal~>pins)~>fig)~>bBox
            pin =dbTransformBBox(bBox schInst~>transform)

            wireId = schCreateWire( sch "draw" "full" list(centerBox(pin) rodAddToX(centerBox(pin) 0.05) )  0.0625 0.0625 0.0 )
            schCreateWireLabel( sch car(wireId) rodAddToX(centerBox(pin) 0.125)  "CP<11>" "lowerLeft" "R0" "stick" 0.0625 nil )

            signal = (setof sig schLib~>signals (member "C8" sig~>sigNames))
            bBox = car(car(signal~>pins)~>fig)~>bBox
            pin =dbTransformBBox(bBox schInst~>transform)

            wireId = schCreateWire( sch "draw" "full" list(centerBox(pin) rodAddToX(centerBox(pin) 0.05) )  0.0625 0.0625 0.0 )
            schCreateWireLabel( sch car(wireId) rodAddToX(centerBox(pin) 0.125)  "CP<11>" "lowerLeft" "R0" "stick" 0.0625 nil )

            signal = (setof sig schLib~>signals (member "C16" sig~>sigNames))
            bBox = car(car(signal~>pins)~>fig)~>bBox
            pin =dbTransformBBox(bBox schInst~>transform)

            wireId = schCreateWire( sch "draw" "full" list(centerBox(pin) rodAddToX(centerBox(pin) 0.05) )  0.0625 0.0625 0.0 )
            schCreateWireLabel( sch car(wireId) rodAddToX(centerBox(pin) 0.125)  "CP<11>" "lowerLeft" "R0" "stick" 0.0625 nil )

            signal = (setof sig schLib~>signals (member "CTOP" sig~>sigNames))
            bBox = car(car(signal~>pins)~>fig)~>bBox
            pin =dbTransformBBox(bBox schInst~>transform)

            wireId = schCreateWire( sch "draw" "full" list(centerBox(pin) rodAddToX(centerBox(pin) 0.05) )  0.0625 0.0625 0.0 )
            schCreateWireLabel( sch car(wireId) rodAddToX(centerBox(pin) 0.125)  "CTOP" "lowerLeft" "R0" "stick" 0.0625 nil )

            signal = (setof sig schLib~>signals (member "AVSS" sig~>sigNames))
            bBox = car(car(signal~>pins)~>fig)~>bBox
            pin =dbTransformBBox(bBox schInst~>transform)

            wireId = schCreateWire( sch "draw" "full" list(centerBox(pin) rodAddToX(centerBox(pin) 0.05) )  0.0625 0.0625 0.0 )
            schCreateWireLabel( sch car(wireId) rodAddToX(centerBox(pin) 0.125)  "AVSS" "lowerLeft" "R0" "stick" 0.0625 nil )

    ;;-------------------------------------------------------------------
    ;; Create instance XC256b<0>
    ;;-------------------------------------------------------------------
        schLib = dbOpenCellViewByType("SAR9B" "CAP32C_CV" "symbol")
        schInst=dbCreateInst(sch schLib "XC256b<0>" xcoord:ycoord "R180")
        xcoord = xcoord  + rightEdge(schLib->bBox) - leftEdge(schLib->bBox) + 1
        if(xcoord > 15 then
                    xcoord = 2
                    ycoord = ycoord +  topEdge(schLib->bBox) - bottomEdge(schLib->bBox) + 1
        )

            signal = (setof sig schLib~>signals (member "C1A" sig~>sigNames))
            bBox = car(car(signal~>pins)~>fig)~>bBox
            pin =dbTransformBBox(bBox schInst~>transform)

            wireId = schCreateWire( sch "draw" "full" list(centerBox(pin) rodAddToX(centerBox(pin) 0.05) )  0.0625 0.0625 0.0 )
            schCreateWireLabel( sch car(wireId) rodAddToX(centerBox(pin) 0.125)  "CP<12>" "lowerLeft" "R0" "stick" 0.0625 nil )

            signal = (setof sig schLib~>signals (member "C1B" sig~>sigNames))
            bBox = car(car(signal~>pins)~>fig)~>bBox
            pin =dbTransformBBox(bBox schInst~>transform)

            wireId = schCreateWire( sch "draw" "full" list(centerBox(pin) rodAddToX(centerBox(pin) 0.05) )  0.0625 0.0625 0.0 )
            schCreateWireLabel( sch car(wireId) rodAddToX(centerBox(pin) 0.125)  "CP<12>" "lowerLeft" "R0" "stick" 0.0625 nil )

            signal = (setof sig schLib~>signals (member "C2" sig~>sigNames))
            bBox = car(car(signal~>pins)~>fig)~>bBox
            pin =dbTransformBBox(bBox schInst~>transform)

            wireId = schCreateWire( sch "draw" "full" list(centerBox(pin) rodAddToX(centerBox(pin) 0.05) )  0.0625 0.0625 0.0 )
            schCreateWireLabel( sch car(wireId) rodAddToX(centerBox(pin) 0.125)  "CP<12>" "lowerLeft" "R0" "stick" 0.0625 nil )

            signal = (setof sig schLib~>signals (member "C4" sig~>sigNames))
            bBox = car(car(signal~>pins)~>fig)~>bBox
            pin =dbTransformBBox(bBox schInst~>transform)

            wireId = schCreateWire( sch "draw" "full" list(centerBox(pin) rodAddToX(centerBox(pin) 0.05) )  0.0625 0.0625 0.0 )
            schCreateWireLabel( sch car(wireId) rodAddToX(centerBox(pin) 0.125)  "CP<12>" "lowerLeft" "R0" "stick" 0.0625 nil )

            signal = (setof sig schLib~>signals (member "C8" sig~>sigNames))
            bBox = car(car(signal~>pins)~>fig)~>bBox
            pin =dbTransformBBox(bBox schInst~>transform)

            wireId = schCreateWire( sch "draw" "full" list(centerBox(pin) rodAddToX(centerBox(pin) 0.05) )  0.0625 0.0625 0.0 )
            schCreateWireLabel( sch car(wireId) rodAddToX(centerBox(pin) 0.125)  "CP<12>" "lowerLeft" "R0" "stick" 0.0625 nil )

            signal = (setof sig schLib~>signals (member "C16" sig~>sigNames))
            bBox = car(car(signal~>pins)~>fig)~>bBox
            pin =dbTransformBBox(bBox schInst~>transform)

            wireId = schCreateWire( sch "draw" "full" list(centerBox(pin) rodAddToX(centerBox(pin) 0.05) )  0.0625 0.0625 0.0 )
            schCreateWireLabel( sch car(wireId) rodAddToX(centerBox(pin) 0.125)  "CP<12>" "lowerLeft" "R0" "stick" 0.0625 nil )

            signal = (setof sig schLib~>signals (member "CTOP" sig~>sigNames))
            bBox = car(car(signal~>pins)~>fig)~>bBox
            pin =dbTransformBBox(bBox schInst~>transform)

            wireId = schCreateWire( sch "draw" "full" list(centerBox(pin) rodAddToX(centerBox(pin) 0.05) )  0.0625 0.0625 0.0 )
            schCreateWireLabel( sch car(wireId) rodAddToX(centerBox(pin) 0.125)  "CTOP" "lowerLeft" "R0" "stick" 0.0625 nil )

            signal = (setof sig schLib~>signals (member "AVSS" sig~>sigNames))
            bBox = car(car(signal~>pins)~>fig)~>bBox
            pin =dbTransformBBox(bBox schInst~>transform)

            wireId = schCreateWire( sch "draw" "full" list(centerBox(pin) rodAddToX(centerBox(pin) 0.05) )  0.0625 0.0625 0.0 )
            schCreateWireLabel( sch car(wireId) rodAddToX(centerBox(pin) 0.125)  "AVSS" "lowerLeft" "R0" "stick" 0.0625 nil )

    ;;-------------------------------------------------------------------
    ;; Create instance XC0
    ;;-------------------------------------------------------------------
        schLib = dbOpenCellViewByType("SAR9B" "CAP32C_CV" "symbol")
        schInst=dbCreateInst(sch schLib "XC0" xcoord:ycoord "R180")
        xcoord = xcoord  + rightEdge(schLib->bBox) - leftEdge(schLib->bBox) + 1
        if(xcoord > 15 then
                    xcoord = 2
                    ycoord = ycoord +  topEdge(schLib->bBox) - bottomEdge(schLib->bBox) + 1
        )

            signal = (setof sig schLib~>signals (member "C1A" sig~>sigNames))
            bBox = car(car(signal~>pins)~>fig)~>bBox
            pin =dbTransformBBox(bBox schInst~>transform)

            wireId = schCreateWire( sch "draw" "full" list(centerBox(pin) rodAddToX(centerBox(pin) 0.05) )  0.0625 0.0625 0.0 )
            schCreateWireLabel( sch car(wireId) rodAddToX(centerBox(pin) 0.125)  "CP<13>" "lowerLeft" "R0" "stick" 0.0625 nil )

            signal = (setof sig schLib~>signals (member "C1B" sig~>sigNames))
            bBox = car(car(signal~>pins)~>fig)~>bBox
            pin =dbTransformBBox(bBox schInst~>transform)

            wireId = schCreateWire( sch "draw" "full" list(centerBox(pin) rodAddToX(centerBox(pin) 0.05) )  0.0625 0.0625 0.0 )
            schCreateWireLabel( sch car(wireId) rodAddToX(centerBox(pin) 0.125)  "CP<13>" "lowerLeft" "R0" "stick" 0.0625 nil )

            signal = (setof sig schLib~>signals (member "C2" sig~>sigNames))
            bBox = car(car(signal~>pins)~>fig)~>bBox
            pin =dbTransformBBox(bBox schInst~>transform)

            wireId = schCreateWire( sch "draw" "full" list(centerBox(pin) rodAddToX(centerBox(pin) 0.05) )  0.0625 0.0625 0.0 )
            schCreateWireLabel( sch car(wireId) rodAddToX(centerBox(pin) 0.125)  "CP<13>" "lowerLeft" "R0" "stick" 0.0625 nil )

            signal = (setof sig schLib~>signals (member "C4" sig~>sigNames))
            bBox = car(car(signal~>pins)~>fig)~>bBox
            pin =dbTransformBBox(bBox schInst~>transform)

            wireId = schCreateWire( sch "draw" "full" list(centerBox(pin) rodAddToX(centerBox(pin) 0.05) )  0.0625 0.0625 0.0 )
            schCreateWireLabel( sch car(wireId) rodAddToX(centerBox(pin) 0.125)  "CP<13>" "lowerLeft" "R0" "stick" 0.0625 nil )

            signal = (setof sig schLib~>signals (member "C8" sig~>sigNames))
            bBox = car(car(signal~>pins)~>fig)~>bBox
            pin =dbTransformBBox(bBox schInst~>transform)

            wireId = schCreateWire( sch "draw" "full" list(centerBox(pin) rodAddToX(centerBox(pin) 0.05) )  0.0625 0.0625 0.0 )
            schCreateWireLabel( sch car(wireId) rodAddToX(centerBox(pin) 0.125)  "CP<13>" "lowerLeft" "R0" "stick" 0.0625 nil )

            signal = (setof sig schLib~>signals (member "C16" sig~>sigNames))
            bBox = car(car(signal~>pins)~>fig)~>bBox
            pin =dbTransformBBox(bBox schInst~>transform)

            wireId = schCreateWire( sch "draw" "full" list(centerBox(pin) rodAddToX(centerBox(pin) 0.05) )  0.0625 0.0625 0.0 )
            schCreateWireLabel( sch car(wireId) rodAddToX(centerBox(pin) 0.125)  "CP<13>" "lowerLeft" "R0" "stick" 0.0625 nil )

            signal = (setof sig schLib~>signals (member "CTOP" sig~>sigNames))
            bBox = car(car(signal~>pins)~>fig)~>bBox
            pin =dbTransformBBox(bBox schInst~>transform)

            wireId = schCreateWire( sch "draw" "full" list(centerBox(pin) rodAddToX(centerBox(pin) 0.05) )  0.0625 0.0625 0.0 )
            schCreateWireLabel( sch car(wireId) rodAddToX(centerBox(pin) 0.125)  "CTOP" "lowerLeft" "R0" "stick" 0.0625 nil )

            signal = (setof sig schLib~>signals (member "AVSS" sig~>sigNames))
            bBox = car(car(signal~>pins)~>fig)~>bBox
            pin =dbTransformBBox(bBox schInst~>transform)

            wireId = schCreateWire( sch "draw" "full" list(centerBox(pin) rodAddToX(centerBox(pin) 0.05) )  0.0625 0.0625 0.0 )
            schCreateWireLabel( sch car(wireId) rodAddToX(centerBox(pin) 0.125)  "AVSS" "lowerLeft" "R0" "stick" 0.0625 nil )

schCheck(sch)
dbSave(sch)
