gdssLibName = "SAR9B"
 pdkLib = "SAR9B"
;- Create cell SARLTX1_CV
(let (layout net fig )
 layout = dbOpenCellViewByType(gdssLibName "SARLTX1_CV" "layout" "maskLayout" "w")
mstr = dbOpenCellViewByType( pdkLib "NCHDL" "layout")
layInst=dbCreateInst(layout mstr "MN0" 0.0:0.0 "R0")
mstr = dbOpenCellViewByType( pdkLib "NCHDL" "layout")
layInst=dbCreateInst(layout mstr "MN1" 0.0:0.344 "R0")
mstr = dbOpenCellViewByType( pdkLib "NCHDL" "layout")
layInst=dbCreateInst(layout mstr "MN2" 0.0:0.688 "R0")
mstr = dbOpenCellViewByType( pdkLib "PCHDL" "layout")
layInst=dbCreateInst(layout mstr "MP0" 1.72:0.0 "R0")
mstr = dbOpenCellViewByType( pdkLib "PCHDL" "layout")
layInst=dbCreateInst(layout mstr "MP1" 1.72:0.344 "R0")
mstr = dbOpenCellViewByType( pdkLib "PCHDL" "layout")
layInst=dbCreateInst(layout mstr "MP2" 1.72:0.688 "R0")
fig = dbCreateRect(layout list(34 -1) list(1.204:0.916 1.446:0.976))
fig = dbCreateRect(layout list(34 -1) list(1.446:0.916 2.236:0.976))
fig = dbCreateRect(layout list(34 -1) list(1.446:0.916 1.506:0.976))
dbCreateLabel(layout list(58 -1) 1.032:0.916 "CHL" "centerLeft" "R0" "stick" 0.1)
fig = dbCreateRect(layout list(34 -1) list(2.808:0.142 2.868:0.89))
dbCreateLabel(layout list(58 -1) 2.666:0.142 "RST_N" "centerLeft" "R0" "stick" 0.1)
fig = dbCreateRect(layout list(34 -1) list(0.43:0.142 0.774:0.202))
net = dbCreateNet(layout "A")
dbCreateTerm( net "A" "inputOutput")
dbCreatePin(net fig)
dbCreateLabel(layout list(34 237) 0.43:0.142 "A" "centerLeft" "R0" "stick" 0.1)
fig = dbCreateRect(layout list(34 -1) list(2.666:0.83 3.01:0.89))
net = dbCreateNet(layout "RST_N")
dbCreateTerm( net "RST_N" "inputOutput")
dbCreatePin(net fig)
dbCreateLabel(layout list(34 237) 2.666:0.83 "RST_N" "centerLeft" "R0" "stick" 0.1)
fig = dbCreateRect(layout list(34 -1) list(0.43:0.83 0.774:0.89))
net = dbCreateNet(layout "EN")
dbCreateTerm( net "EN" "inputOutput")
dbCreatePin(net fig)
dbCreateLabel(layout list(34 237) 0.43:0.83 "EN" "centerLeft" "R0" "stick" 0.1)
fig = dbCreateRect(layout list(34 -1) list(0.43:0.486 0.774:0.546))
net = dbCreateNet(layout "LCK_N")
dbCreateTerm( net "LCK_N" "inputOutput")
dbCreatePin(net fig)
dbCreateLabel(layout list(34 237) 0.43:0.486 "LCK_N" "centerLeft" "R0" "stick" 0.1)
fig = dbCreateRect(layout list(34 -1) list(1.032:0.916 1.376:0.976))
net = dbCreateNet(layout "CHL")
dbCreateTerm( net "CHL" "inputOutput")
dbCreatePin(net fig)
dbCreateLabel(layout list(34 237) 1.032:0.916 "CHL" "centerLeft" "R0" "stick" 0.1)
fig = dbCreateRect(layout list(46 -1) list(2.064:0.0 2.394:1.032))
net = dbCreateNet(layout "AVDD")
dbCreateTerm( net "AVDD" "inputOutput")
dbCreatePin(net fig)
dbCreateLabel(layout list(46 237) 2.064:0.0 "AVDD" "centerLeft" "R0" "stick" 0.1)
fig = dbCreateRect(layout list(46 -1) list(1.032:0.0 1.362:1.032))
net = dbCreateNet(layout "AVSS")
dbCreateTerm( net "AVSS" "inputOutput")
dbCreatePin(net fig)
dbCreateLabel(layout list(46 237) 1.032:0.0 "AVSS" "centerLeft" "R0" "stick" 0.1)
mstr = dbOpenCellViewByType( pdkLib "cut_M1M4_2x1" "layout")
layInst=dbCreateInst(layout mstr "" 2.064:0.056 "R0")
fig = dbCreateRect(layout list(46 -1) list(2.064:0.0 2.394:1.032))
mstr = dbOpenCellViewByType( pdkLib "cut_M1M4_2x1" "layout")
layInst=dbCreateInst(layout mstr "" 1.032:0.056 "R0")
fig = dbCreateRect(layout list(46 -1) list(1.032:0.0 1.362:1.032))
 dbSave(layout) )
