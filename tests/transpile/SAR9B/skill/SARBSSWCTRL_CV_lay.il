gdssLibName = "SAR9B"
 pdkLib = "SAR9B"
;- Create cell SARBSSWCTRL_CV
(let (layout net fig )
 layout = dbOpenCellViewByType(gdssLibName "SARBSSWCTRL_CV" "layout" "maskLayout" "w")
mstr = dbOpenCellViewByType( pdkLib "NCHDL" "layout")
layInst=dbCreateInst(layout mstr "MN0" 0.0:0.0 "R0")
mstr = dbOpenCellViewByType( pdkLib "NCHDL" "layout")
layInst=dbCreateInst(layout mstr "MN1" 0.0:0.344 "R0")
mstr = dbOpenCellViewByType( pdkLib "PCHDL" "layout")
layInst=dbCreateInst(layout mstr "MP0" 1.72:0.0 "R0")
mstr = dbOpenCellViewByType( pdkLib "PCHDL" "layout")
layInst=dbCreateInst(layout mstr "MP1" 1.72:0.344 "R0")
fig = dbCreateRect(layout list(30 -1) list(0.774:0.157 2.666:0.187))
dbCreateLabel(layout list(58 -1) 0.774:0.157 "C" "centerLeft" "R0" "stick" 0.1)
fig = dbCreateRect(layout list(34 -1) list(1.204:0.572 1.446:0.632))
fig = dbCreateRect(layout list(34 -1) list(1.446:0.056 2.236:0.116))
fig = dbCreateRect(layout list(34 -1) list(1.446:0.056 1.506:0.632))
dbCreateLabel(layout list(58 -1) 1.032:0.572 "GN" "centerLeft" "R0" "stick" 0.1)
fig = dbCreateRect(layout list(34 -1) list(2.236:0.056 2.478:0.116))
fig = dbCreateRect(layout list(34 -1) list(2.478:0.486 2.838:0.546))
fig = dbCreateRect(layout list(34 -1) list(2.478:0.056 2.538:0.546))
dbCreateLabel(layout list(58 -1) 2.064:0.056 "GN" "centerLeft" "R0" "stick" 0.1)
fig = dbCreateRect(layout list(34 -1) list(2.064:0.228 2.408:0.288))
net = dbCreateNet(layout "GNG")
dbCreateTerm( net "GNG" "inputOutput")
dbCreatePin(net fig)
dbCreateLabel(layout list(34 237) 2.064:0.228 "GNG" "centerLeft" "R0" "stick" 0.1)
fig = dbCreateRect(layout list(34 -1) list(0.43:0.486 0.774:0.546))
net = dbCreateNet(layout "TIE_H")
dbCreateTerm( net "TIE_H" "inputOutput")
dbCreatePin(net fig)
dbCreateLabel(layout list(34 237) 0.43:0.486 "TIE_H" "centerLeft" "R0" "stick" 0.1)
fig = dbCreateRect(layout list(34 -1) list(2.666:0.142 3.01:0.202))
net = dbCreateNet(layout "C")
dbCreateTerm( net "C" "inputOutput")
dbCreatePin(net fig)
dbCreateLabel(layout list(34 237) 2.666:0.142 "C" "centerLeft" "R0" "stick" 0.1)
fig = dbCreateRect(layout list(34 -1) list(1.032:0.572 1.376:0.632))
net = dbCreateNet(layout "GN")
dbCreateTerm( net "GN" "inputOutput")
dbCreatePin(net fig)
dbCreateLabel(layout list(34 237) 1.032:0.572 "GN" "centerLeft" "R0" "stick" 0.1)
fig = dbCreateRect(layout list(46 -1) list(2.064:0.0 2.394:0.688))
net = dbCreateNet(layout "AVDD")
dbCreateTerm( net "AVDD" "inputOutput")
dbCreatePin(net fig)
dbCreateLabel(layout list(46 237) 2.064:0.0 "AVDD" "centerLeft" "R0" "stick" 0.1)
fig = dbCreateRect(layout list(46 -1) list(1.032:0.0 1.362:0.688))
net = dbCreateNet(layout "AVSS")
dbCreateTerm( net "AVSS" "inputOutput")
dbCreatePin(net fig)
dbCreateLabel(layout list(46 237) 1.032:0.0 "AVSS" "centerLeft" "R0" "stick" 0.1)
mstr = dbOpenCellViewByType( pdkLib "cut_M1M4_2x1" "layout")
layInst=dbCreateInst(layout mstr "" 2.064:0.572 "R0")
fig = dbCreateRect(layout list(46 -1) list(2.064:0.0 2.394:0.688))
mstr = dbOpenCellViewByType( pdkLib "cut_M1M4_2x1" "layout")
layInst=dbCreateInst(layout mstr "" 1.032:0.056 "R0")
fig = dbCreateRect(layout list(46 -1) list(1.032:0.0 1.362:0.688))
 dbSave(layout) )
