gdssLibName = "SAR9B"
 pdkLib = "SAR9B"
;- Create cell SARCMPX1_CV
(let (layout net fig )
 layout = dbOpenCellViewByType(gdssLibName "SARCMPX1_CV" "layout" "maskLayout" "w")
mstr = dbOpenCellViewByType( pdkLib "TAPCELL_CV" "layout")
layInst=dbCreateInst(layout mstr "XA0" 0.0:0.0 "R0")
mstr = dbOpenCellViewByType( pdkLib "SARKICKHX1_CV" "layout")
layInst=dbCreateInst(layout mstr "XA1" 0.0:0.344 "R0")
mstr = dbOpenCellViewByType( pdkLib "SARCMPHX1_CV" "layout")
layInst=dbCreateInst(layout mstr "XA2" 0.0:2.752 "R0")
mstr = dbOpenCellViewByType( pdkLib "IVX4_CV" "layout")
layInst=dbCreateInst(layout mstr "XA2a" 0.0:5.16 "R0")
mstr = dbOpenCellViewByType( pdkLib "IVX4_CV" "layout")
layInst=dbCreateInst(layout mstr "XA3a" 0.0:6.536 "R0")
mstr = dbOpenCellViewByType( pdkLib "SARCMPHX1_CV" "layout")
layInst=dbCreateInst(layout mstr "XA3" 0.0:7.912 "R0")
mstr = dbOpenCellViewByType( pdkLib "SARKICKHX1_CV" "layout")
layInst=dbCreateInst(layout mstr "XA4" 0.0:10.32 "R0")
mstr = dbOpenCellViewByType( pdkLib "IVX1_CV" "layout")
layInst=dbCreateInst(layout mstr "XA9" 0.0:12.728 "R0")
mstr = dbOpenCellViewByType( pdkLib "NDX1_CV" "layout")
layInst=dbCreateInst(layout mstr "XA10" 0.0:13.072 "R0")
mstr = dbOpenCellViewByType( pdkLib "NRX1_CV" "layout")
layInst=dbCreateInst(layout mstr "XA11" 0.0:13.76 "R0")
mstr = dbOpenCellViewByType( pdkLib "IVX1_CV" "layout")
layInst=dbCreateInst(layout mstr "XA12" 0.0:14.448 "R0")
mstr = dbOpenCellViewByType( pdkLib "TAPCELL_CV" "layout")
layInst=dbCreateInst(layout mstr "XA13" 0.0:14.792 "R0")
fig = dbCreateRect(layout list(34 -1) list(2.236:4.872 2.478:4.932))
fig = dbCreateRect(layout list(34 -1) list(2.478:9.43 2.838:9.49))
fig = dbCreateRect(layout list(34 -1) list(2.478:6.678 2.838:6.738))
fig = dbCreateRect(layout list(34 -1) list(2.478:4.872 2.538:9.49))
dbCreateLabel(layout list(58 -1) 2.064:4.872 "CNO_I" "centerLeft" "R0" "stick" 0.1)
mstr = dbOpenCellViewByType( pdkLib "cut_M1M2_2x1" "layout")
layInst=dbCreateInst(layout mstr "" 2.064:9.344 "R0")
mstr = dbOpenCellViewByType( pdkLib "cut_M1M2_2x1" "layout")
layInst=dbCreateInst(layout mstr "" 2.666:4.614 "R0")
mstr = dbOpenCellViewByType( pdkLib "cut_M1M2_2x1" "layout")
layInst=dbCreateInst(layout mstr "" 2.666:5.302 "R0")
fig = dbCreateRect(layout list(36 -1) list(2.236:9.344 2.478:9.404))
fig = dbCreateRect(layout list(36 -1) list(2.478:4.614 2.838:4.674))
fig = dbCreateRect(layout list(36 -1) list(2.478:5.302 2.838:5.362))
fig = dbCreateRect(layout list(36 -1) list(2.478:4.614 2.538:9.404))
dbCreateLabel(layout list(58 -1) 2.064:9.344 "CPO_I" "centerLeft" "R0" "stick" 0.1)
mstr = dbOpenCellViewByType( pdkLib "cut_M1M2_2x1" "layout")
layInst=dbCreateInst(layout mstr "" 0.444:2.206 "R0")
mstr = dbOpenCellViewByType( pdkLib "cut_M1M2_2x1" "layout")
layInst=dbCreateInst(layout mstr "" 0.444:3.238 "R0")
fig = dbCreateRect(layout list(36 -1) list(0.602:2.206 0.844:2.266))
fig = dbCreateRect(layout list(36 -1) list(0.602:3.238 0.844:3.298))
fig = dbCreateRect(layout list(36 -1) list(0.844:2.206 0.904:3.298))
dbCreateLabel(layout list(58 -1) 0.43:2.206 "CNI" "centerLeft" "R0" "stick" 0.1)
mstr = dbOpenCellViewByType( pdkLib "cut_M1M2_2x1" "layout")
layInst=dbCreateInst(layout mstr "" 0.444:9.774 "R0")
mstr = dbOpenCellViewByType( pdkLib "cut_M1M2_2x1" "layout")
layInst=dbCreateInst(layout mstr "" 0.444:10.806 "R0")
fig = dbCreateRect(layout list(36 -1) list(0.602:9.774 0.844:9.834))
fig = dbCreateRect(layout list(36 -1) list(0.602:10.806 0.844:10.866))
fig = dbCreateRect(layout list(36 -1) list(0.844:9.774 0.904:10.866))
dbCreateLabel(layout list(58 -1) 0.43:9.774 "CPI" "centerLeft" "R0" "stick" 0.1)
fig = dbCreateRect(layout list(34 -1) list(0.3:2.55 0.602:2.61))
fig = dbCreateRect(layout list(34 -1) list(0.3:2.894 0.602:2.954))
fig = dbCreateRect(layout list(34 -1) list(0.3:8.054 0.602:8.114))
fig = dbCreateRect(layout list(34 -1) list(0.3:12.526 0.602:12.586))
fig = dbCreateRect(layout list(34 -1) list(0.3:2.55 0.36:12.586))
dbCreateLabel(layout list(58 -1) 0.43:2.55 "CK_B" "centerLeft" "R0" "stick" 0.1)
fig = dbCreateRect(layout list(34 -1) list(0.602:12.526 0.844:12.586))
fig = dbCreateRect(layout list(34 -1) list(0.844:12.956 1.204:13.016))
fig = dbCreateRect(layout list(34 -1) list(0.844:12.526 0.904:13.016))
dbCreateLabel(layout list(58 -1) 0.43:12.526 "CK_B" "centerLeft" "R0" "stick" 0.1)
mstr = dbOpenCellViewByType( pdkLib "cut_M1M2_2x1" "layout")
layInst=dbCreateInst(layout mstr "" 0.43:0.486 "R0")
mstr = dbOpenCellViewByType( pdkLib "cut_M1M2_2x1" "layout")
layInst=dbCreateInst(layout mstr "" 0.43:10.462 "R0")
mstr = dbOpenCellViewByType( pdkLib "cut_M1M2_2x1" "layout")
layInst=dbCreateInst(layout mstr "" 0.43:12.87 "R0")
fig = dbCreateRect(layout list(36 -1) list(0.3:0.486 0.602:0.546))
fig = dbCreateRect(layout list(36 -1) list(0.3:10.462 0.602:10.522))
fig = dbCreateRect(layout list(36 -1) list(0.3:12.87 0.602:12.93))
fig = dbCreateRect(layout list(36 -1) list(0.3:0.486 0.36:12.93))
dbCreateLabel(layout list(58 -1) 0.43:0.486 "CK_N" "centerLeft" "R0" "stick" 0.1)
mstr = dbOpenCellViewByType( pdkLib "cut_M1M2_2x1" "layout")
layInst=dbCreateInst(layout mstr "" 0.43:12.87 "R0")
mstr = dbOpenCellViewByType( pdkLib "cut_M1M2_2x1" "layout")
layInst=dbCreateInst(layout mstr "" 1.032:13.644 "R0")
fig = dbCreateRect(layout list(36 -1) list(0.602:12.87 0.844:12.93))
fig = dbCreateRect(layout list(36 -1) list(0.844:13.644 1.204:13.704))
fig = dbCreateRect(layout list(36 -1) list(0.844:12.87 0.904:13.704))
dbCreateLabel(layout list(58 -1) 0.43:12.87 "CK_N" "centerLeft" "R0" "stick" 0.1)
fig = dbCreateRect(layout list(34 -1) list(0.902:14.16 1.204:14.22))
fig = dbCreateRect(layout list(34 -1) list(0.602:13.214 0.902:13.274))
fig = dbCreateRect(layout list(34 -1) list(0.902:13.214 0.962:14.22))
dbCreateLabel(layout list(58 -1) 1.032:14.16 "DONE_N" "centerLeft" "R0" "stick" 0.1)
fig = dbCreateRect(layout list(34 -1) list(2.236:14.676 2.478:14.736))
fig = dbCreateRect(layout list(34 -1) list(2.478:13.558 2.838:13.618))
fig = dbCreateRect(layout list(34 -1) list(2.478:13.558 2.538:14.736))
dbCreateLabel(layout list(58 -1) 2.064:14.676 "CK_A" "centerLeft" "R0" "stick" 0.1)
fig = dbCreateRect(layout list(34 -1) list(0.902:4.356 1.204:4.416))
fig = dbCreateRect(layout list(34 -1) list(0.902:9.516 1.204:9.576))
fig = dbCreateRect(layout list(34 -1) list(0.902:4.356 0.962:9.576))
dbCreateLabel(layout list(58 -1) 1.032:4.356 "N1" "centerLeft" "R0" "stick" 0.1)
fig = dbCreateRect(layout list(34 -1) list(0.43:13.902 0.774:13.962))
net = dbCreateNet(layout "CK_SAMPLE")
dbCreateTerm( net "CK_SAMPLE" "inputOutput")
dbCreatePin(net fig)
dbCreateLabel(layout list(34 237) 0.43:13.902 "CK_SAMPLE" "centerLeft" "R0" "stick" 0.1)
fig = dbCreateRect(layout list(34 -1) list(0.43:14.59 0.774:14.65))
net = dbCreateNet(layout "CK_CMP")
dbCreateTerm( net "CK_CMP" "inputOutput")
dbCreatePin(net fig)
dbCreateLabel(layout list(34 237) 0.43:14.59 "CK_CMP" "centerLeft" "R0" "stick" 0.1)
fig = dbCreateRect(layout list(34 -1) list(0.43:14.246 0.774:14.306))
net = dbCreateNet(layout "DONE")
dbCreateTerm( net "DONE" "inputOutput")
dbCreatePin(net fig)
dbCreateLabel(layout list(34 237) 0.43:14.246 "DONE" "centerLeft" "R0" "stick" 0.1)
fig = dbCreateRect(layout list(34 -1) list(1.032:6.764 1.376:6.824))
net = dbCreateNet(layout "CNO")
dbCreateTerm( net "CNO" "inputOutput")
dbCreatePin(net fig)
dbCreateLabel(layout list(34 237) 1.032:6.764 "CNO" "centerLeft" "R0" "stick" 0.1)
fig = dbCreateRect(layout list(34 -1) list(1.032:5.388 1.376:5.448))
net = dbCreateNet(layout "CPO")
dbCreateTerm( net "CPO" "inputOutput")
dbCreatePin(net fig)
dbCreateLabel(layout list(34 237) 1.032:5.388 "CPO" "centerLeft" "R0" "stick" 0.1)
fig = dbCreateRect(layout list(34 -1) list(0.43:2.206 0.774:2.266))
net = dbCreateNet(layout "CPI")
dbCreateTerm( net "CPI" "inputOutput")
dbCreatePin(net fig)
dbCreateLabel(layout list(34 237) 0.43:2.206 "CPI" "centerLeft" "R0" "stick" 0.1)
fig = dbCreateRect(layout list(34 -1) list(0.43:9.774 0.774:9.834))
net = dbCreateNet(layout "CNI")
dbCreateTerm( net "CNI" "inputOutput")
dbCreatePin(net fig)
dbCreateLabel(layout list(34 237) 0.43:9.774 "CNI" "centerLeft" "R0" "stick" 0.1)
fig = dbCreateRect(layout list(46 -1) list(2.064:0.0 2.394:15.136))
net = dbCreateNet(layout "AVDD")
dbCreateTerm( net "AVDD" "inputOutput")
dbCreatePin(net fig)
dbCreateLabel(layout list(46 237) 2.064:0.0 "AVDD" "centerLeft" "R0" "stick" 0.1)
fig = dbCreateRect(layout list(46 -1) list(1.032:0.0 1.362:15.136))
net = dbCreateNet(layout "AVSS")
dbCreateTerm( net "AVSS" "inputOutput")
dbCreatePin(net fig)
dbCreateLabel(layout list(46 237) 1.032:0.0 "AVSS" "centerLeft" "R0" "stick" 0.1)
fig = dbCreateRect(layout list(46 -1) list(2.064:0.0 2.394:15.136))
mstr = dbOpenCellViewByType( pdkLib "cut_M1M4_2x1" "layout")
layInst=dbCreateInst(layout mstr "" 1.032:0.228 "R0")
mstr = dbOpenCellViewByType( pdkLib "cut_M1M4_2x1" "layout")
layInst=dbCreateInst(layout mstr "" 1.032:15.02 "R0")
fig = dbCreateRect(layout list(46 -1) list(1.032:0.0 1.362:15.136))
 dbSave(layout) )
