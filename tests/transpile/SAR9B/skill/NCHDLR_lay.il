gdssLibName = "SAR9B"
 pdkLib = "SAR9B"
;- Create cell NCHDLR
(let (layout net fig )
 layout = dbOpenCellViewByType(gdssLibName "NCHDLR" "layout" "maskLayout" "w")
fig = dbCreateRect(layout list(22 -1) list(-0.172:-0.043 0.172:0.043))
fig = dbCreateRect(layout list(22 -1) list(-0.172:0.043 0.172:0.129))
fig = dbCreateRect(layout list(33 -1) list(-0.106:0.066 -0.066:0.106))
fig = dbCreateRect(layout list(33 -1) list(0.066:0.066 0.106:0.106))
fig = dbCreateRect(layout list(22 -1) list(1.118:0.043 1.376:0.129))
fig = dbCreateRect(layout list(33 -1) list(1.184:0.066 1.224:0.106))
fig = dbCreateRect(layout list(33 -1) list(1.284:0.066 1.324:0.106))
fig = dbCreateRect(layout list(22 -1) list(-0.172:0.129 0.172:0.215))
fig = dbCreateRect(layout list(22 -1) list(1.118:0.129 1.376:0.215))
fig = dbCreateRect(layout list(22 -1) list(-0.172:0.215 0.172:0.301))
fig = dbCreateRect(layout list(33 -1) list(-0.106:0.238 -0.066:0.278))
fig = dbCreateRect(layout list(33 -1) list(0.066:0.238 0.106:0.278))
fig = dbCreateRect(layout list(22 -1) list(1.118:0.215 1.376:0.301))
fig = dbCreateRect(layout list(33 -1) list(1.184:0.238 1.224:0.278))
fig = dbCreateRect(layout list(33 -1) list(1.284:0.238 1.324:0.278))
fig = dbCreateRect(layout list(22 -1) list(-0.172:0.301 0.172:0.387))
fig = dbCreateRect(layout list(30 -1) list(0.516:-0.015 1.634:0.015))
fig = dbCreateRect(layout list(30 -1) list(0.516:0.142 0.774:0.202))
fig = dbCreateRect(layout list(33 -1) list(0.539:0.152 0.579:0.192))
fig = dbCreateRect(layout list(33 -1) list(0.711:0.152 0.751:0.192))
fig = dbCreateRect(layout list(30 -1) list(0.774:0.157 1.634:0.187))
fig = dbCreateRect(layout list(34 -1) list(0.43:0.142 0.774:0.202))
net = dbCreateNet(layout "G")
dbCreateTerm( net "G" "inputOutput")
dbCreatePin(net fig)
dbCreateLabel(layout list(34 237) 0.43:0.142 "G" "centerLeft" "R0" "stick" 0.1)
fig = dbCreateRect(layout list(30 -1) list(0.516:0.329 1.634:0.359))
fig = dbCreateRect(layout list(34 -1) list(-0.172:-0.043 0.172:0.043))
fig = dbCreateRect(layout list(34 -1) list(-0.172:0.043 0.172:0.129))
fig = dbCreateRect(layout list(34 -1) list(1.032:0.056 1.376:0.116))
fig = dbCreateRect(layout list(34 -1) list(1.032:0.056 1.376:0.116))
net = dbCreateNet(layout "S")
dbCreateTerm( net "S" "inputOutput")
dbCreatePin(net fig)
dbCreateLabel(layout list(34 237) 1.032:0.056 "S" "centerLeft" "R0" "stick" 0.1)
fig = dbCreateRect(layout list(34 -1) list(-0.172:0.129 0.172:0.215))
fig = dbCreateRect(layout list(34 -1) list(-0.172:0.129 0.172:0.215))
net = dbCreateNet(layout "B")
dbCreateTerm( net "B" "inputOutput")
dbCreatePin(net fig)
dbCreateLabel(layout list(34 237) -0.172:0.129 "B" "centerLeft" "R0" "stick" 0.1)
fig = dbCreateRect(layout list(34 -1) list(0.43:0.142 0.774:0.202))
fig = dbCreateRect(layout list(34 -1) list(-0.172:0.215 0.172:0.301))
fig = dbCreateRect(layout list(34 -1) list(1.032:0.228 1.376:0.288))
fig = dbCreateRect(layout list(34 -1) list(1.032:0.228 1.376:0.288))
net = dbCreateNet(layout "D")
dbCreateTerm( net "D" "inputOutput")
dbCreatePin(net fig)
dbCreateLabel(layout list(34 237) 1.032:0.228 "D" "centerLeft" "R0" "stick" 0.1)
fig = dbCreateRect(layout list(34 -1) list(-0.172:0.301 0.172:0.387))
fig = dbCreateRect(layout list(21 -1) list(0.998:-0.077 1.496:0.421))
fig = dbCreateRect(layout list(21 -1) list(-0.292:-0.163 1.668:0.507))
fig = dbCreateRect(layout list(21 -1) list(-0.292:-0.163 1.668:0.507))
fig = dbCreateRect(layout list(21 -1) list(-0.292:-0.163 0.292:0.507))
fig = dbCreateRect(layout list(21 -1) list(-0.292:-0.163 1.84:0.507))
fig = dbCreateRect(layout list(21 -1) list(-0.292:-0.163 1.84:0.507))
 dbSave(layout) )
