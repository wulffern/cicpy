gdssLibName = "SAR9B"
 pdkLib = "SAR9B"
;- Create cell SWX4_CV
(let (layout net fig )
 layout = dbOpenCellViewByType(gdssLibName "SWX4_CV" "layout" "maskLayout" "w")
mstr = dbOpenCellViewByType( pdkLib "NCHDL" "layout")
layInst=dbCreateInst(layout mstr "MN0" 0.0:0.0 "R0")
mstr = dbOpenCellViewByType( pdkLib "NCHDL" "layout")
layInst=dbCreateInst(layout mstr "MN1" 0.0:0.344 "R0")
mstr = dbOpenCellViewByType( pdkLib "NCHDL" "layout")
layInst=dbCreateInst(layout mstr "MN2" 0.0:0.688 "R0")
mstr = dbOpenCellViewByType( pdkLib "NCHDL" "layout")
layInst=dbCreateInst(layout mstr "MN3" 0.0:1.032 "R0")
mstr = dbOpenCellViewByType( pdkLib "PCHDL" "layout")
layInst=dbCreateInst(layout mstr "MP0" 1.72:0.0 "R0")
mstr = dbOpenCellViewByType( pdkLib "PCHDL" "layout")
layInst=dbCreateInst(layout mstr "MP1" 1.72:0.344 "R0")
mstr = dbOpenCellViewByType( pdkLib "PCHDL" "layout")
layInst=dbCreateInst(layout mstr "MP2" 1.72:0.688 "R0")
mstr = dbOpenCellViewByType( pdkLib "PCHDL" "layout")
layInst=dbCreateInst(layout mstr "MP3" 1.72:1.032 "R0")
mstr = dbOpenCellViewByType( pdkLib "cut_M3M4_2x1" "layout")
layInst=dbCreateInst(layout mstr "" 2.752:0.572 "R0")
fig = dbCreateRect(layout list(34 -1) list(1.204:0.228 1.446:0.288))
fig = dbCreateRect(layout list(34 -1) list(1.204:0.916 1.446:0.976))
fig = dbCreateRect(layout list(34 -1) list(1.446:0.228 2.236:0.288))
fig = dbCreateRect(layout list(34 -1) list(1.446:0.916 2.236:0.976))
fig = dbCreateRect(layout list(34 -1) list(1.446:0.228 1.506:0.976))
dbCreateLabel(layout list(58 -1) 1.032:0.228 "Y" "centerLeft" "R0" "stick" 0.1)
fig = dbCreateRect(layout list(30 -1) list(0.774:0.157 2.666:0.187))
fig = dbCreateRect(layout list(30 -1) list(0.774:0.501 2.666:0.531))
fig = dbCreateRect(layout list(30 -1) list(0.774:0.845 2.666:0.875))
fig = dbCreateRect(layout list(30 -1) list(0.774:1.189 2.666:1.219))
dbCreateLabel(layout list(58 -1) 0.774:0.157 "A" "centerLeft" "R0" "stick" 0.1)
fig = dbCreateRect(layout list(34 -1) list(0.572:0.142 0.632:1.234))
dbCreateLabel(layout list(58 -1) 0.43:0.142 "A" "centerLeft" "R0" "stick" 0.1)
fig = dbCreateRect(layout list(34 -1) list(2.808:0.142 2.868:1.234))
dbCreateLabel(layout list(58 -1) 2.666:0.142 "A" "centerLeft" "R0" "stick" 0.1)
mstr = dbOpenCellViewByType( pdkLib "cut_M1M3_2x1" "layout")
layInst=dbCreateInst(layout mstr "" 2.064:0.056 "R0")
mstr = dbOpenCellViewByType( pdkLib "cut_M1M3_2x1" "layout")
layInst=dbCreateInst(layout mstr "" 2.064:0.572 "R0")
mstr = dbOpenCellViewByType( pdkLib "cut_M1M3_2x1" "layout")
layInst=dbCreateInst(layout mstr "" 2.064:1.26 "R0")
mstr = dbOpenCellViewByType( pdkLib "cut_M3M4_2x1" "layout")
layInst=dbCreateInst(layout mstr "" 2.752:0.572 "R0")
fig = dbCreateRect(layout list(42 -1) list(2.236:0.056 2.478:0.116))
fig = dbCreateRect(layout list(42 -1) list(2.236:0.572 2.478:0.632))
fig = dbCreateRect(layout list(42 -1) list(2.236:1.26 2.478:1.32))
fig = dbCreateRect(layout list(42 -1) list(2.478:0.572 2.917:0.632))
fig = dbCreateRect(layout list(42 -1) list(2.478:0.056 2.538:1.32))
dbCreateLabel(layout list(58 -1) 2.064:0.056 "VREF" "centerLeft" "R0" "stick" 0.1)
fig = dbCreateRect(layout list(34 -1) list(0.43:0.142 0.774:0.202))
net = dbCreateNet(layout "A")
dbCreateTerm( net "A" "inputOutput")
dbCreatePin(net fig)
dbCreateLabel(layout list(34 237) 0.43:0.142 "A" "centerLeft" "R0" "stick" 0.1)
fig = dbCreateRect(layout list(34 -1) list(1.032:0.228 1.376:0.288))
net = dbCreateNet(layout "Y")
dbCreateTerm( net "Y" "inputOutput")
dbCreatePin(net fig)
dbCreateLabel(layout list(34 237) 1.032:0.228 "Y" "centerLeft" "R0" "stick" 0.1)
fig = dbCreateRect(layout list(46 -1) list(2.752:0.572 3.082:0.622))
net = dbCreateNet(layout "VREF")
dbCreateTerm( net "VREF" "inputOutput")
dbCreatePin(net fig)
dbCreateLabel(layout list(46 237) 2.752:0.572 "VREF" "centerLeft" "R0" "stick" 0.1)
fig = dbCreateRect(layout list(46 -1) list(1.032:0.0 1.362:1.376))
net = dbCreateNet(layout "AVSS")
dbCreateTerm( net "AVSS" "inputOutput")
dbCreatePin(net fig)
dbCreateLabel(layout list(46 237) 1.032:0.0 "AVSS" "centerLeft" "R0" "stick" 0.1)
mstr = dbOpenCellViewByType( pdkLib "cut_M1M4_2x1" "layout")
layInst=dbCreateInst(layout mstr "" 1.032:0.056 "R0")
mstr = dbOpenCellViewByType( pdkLib "cut_M1M4_2x1" "layout")
layInst=dbCreateInst(layout mstr "" 1.032:0.572 "R0")
mstr = dbOpenCellViewByType( pdkLib "cut_M1M4_2x1" "layout")
layInst=dbCreateInst(layout mstr "" 1.032:0.744 "R0")
mstr = dbOpenCellViewByType( pdkLib "cut_M1M4_2x1" "layout")
layInst=dbCreateInst(layout mstr "" 1.032:1.26 "R0")
fig = dbCreateRect(layout list(46 -1) list(1.032:0.0 1.362:1.376))
 dbSave(layout) )
