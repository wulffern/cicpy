gdssLibName = "SAR9B"
 pdkLib = "SAR9B"
;- Create cell CAPR
(let (layout net fig )
 layout = dbOpenCellViewByType(gdssLibName "CAPR" "layout" "maskLayout" "w")
fig = dbCreateRect(layout list(34 -1) list(0.043:0.142 1.333:0.202))
fig = dbCreateRect(layout list(35 -1) list(0.749:0.147 0.799:0.197))
fig = dbCreateRect(layout list(35 -1) list(0.619:0.147 0.669:0.197))
fig = dbCreateRect(layout list(34 -1) list(0.043:0.314 1.333:0.374))
fig = dbCreateRect(layout list(35 -1) list(0.749:0.319 0.799:0.369))
fig = dbCreateRect(layout list(35 -1) list(0.619:0.319 0.669:0.369))
fig = dbCreateRect(layout list(36 -1) list(0.043:0.129 1.677:0.215))
fig = dbCreateRect(layout list(38 -1) list(0.835:0.147 0.885:0.197))
fig = dbCreateRect(layout list(38 -1) list(0.705:0.147 0.755:0.197))
fig = dbCreateRect(layout list(36 -1) list(0.043:0.301 1.677:0.387))
fig = dbCreateRect(layout list(38 -1) list(0.835:0.319 0.885:0.369))
fig = dbCreateRect(layout list(38 -1) list(0.705:0.319 0.755:0.369))
fig = dbCreateRect(layout list(42 -1) list(-0.043:0.129 0.215:0.215))
fig = dbCreateRect(layout list(40 -1) list(-0.025:0.147 0.025:0.197))
fig = dbCreateRect(layout list(40 -1) list(-0.155:0.147 -0.105:0.197))
fig = dbCreateRect(layout list(42 -1) list(0.215:0.129 0.387:0.215))
fig = dbCreateRect(layout list(110 13) list(0.215:0.129 0.301:0.215))
fig = dbCreateRect(layout list(42 -1) list(0.473:0.129 1.591:0.215))
fig = dbCreateRect(layout list(42 -1) list(1.591:0.129 1.763:0.215))
fig = dbCreateRect(layout list(110 13) list(1.591:0.129 1.677:0.215))
fig = dbCreateRect(layout list(42 -1) list(0.301:0.215 0.387:0.301))
fig = dbCreateRect(layout list(42 -1) list(1.677:0.215 1.763:0.301))
net = dbCreateNet(layout "B")
dbCreateTerm( net "B" "inputOutput")
dbCreatePin(net fig)
dbCreateLabel(layout list(42 237) 1.677:0.215 "B" "centerLeft" "R0" "stick" 0.1)
fig = dbCreateRect(layout list(42 -1) list(1.677:0.215 1.763:0.301))
fig = dbCreateRect(layout list(42 -1) list(0.129:0.301 1.333:0.387))
fig = dbCreateRect(layout list(42 -1) list(1.419:0.301 1.763:0.387))
fig = dbCreateRect(layout list(40 -1) list(1.609:0.319 1.659:0.369))
fig = dbCreateRect(layout list(40 -1) list(1.479:0.319 1.529:0.369))
fig = dbCreateRect(layout list(46 -1) list(-0.043:0.142 1.763:0.202))
fig = dbCreateRect(layout list(46 -1) list(-0.043:0.142 1.763:0.202))
net = dbCreateNet(layout "A")
dbCreateTerm( net "A" "inputOutput")
dbCreatePin(net fig)
dbCreateLabel(layout list(46 237) -0.043:0.142 "A" "centerLeft" "R0" "stick" 0.1)
fig = dbCreateRect(layout list(46 -1) list(-0.043:0.314 1.763:0.374))
 dbSave(layout) )
